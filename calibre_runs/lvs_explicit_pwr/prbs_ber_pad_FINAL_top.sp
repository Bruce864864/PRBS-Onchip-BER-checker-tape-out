* SPICE NETLIST
***************************************

.SUBCKT crtmom PLUS MINUS BULK
.ENDS
***************************************
.SUBCKT cfmom PLUS MINUS BULK
.ENDS
***************************************
.SUBCKT cfmom_rf PLUS MINUS BULK
.ENDS
***************************************
.SUBCKT cfmom_mx PLUS1 MINUS1 PLUS2 MINUS2 BULK
.ENDS
***************************************
.SUBCKT lcesd1_rf PLUS MINUS
.ENDS
***************************************
.SUBCKT lcesd2_rf PLUS MINUS
.ENDS
***************************************
.SUBCKT mimcap_2p0_shield PLUS MINUS BULK
.ENDS
***************************************
.SUBCKT mimcap_2p0_sin TOP BOT
.ENDS
***************************************
.SUBCKT mimcap_2p0_sin_3t PLUS MINUS BULK
.ENDS
***************************************
.SUBCKT mimcap_2p0_wos PLUS MINUS BULK
.ENDS
***************************************
.SUBCKT moscap_rf PLUS MINUS BULK
.ENDS
***************************************
.SUBCKT moscap_rf33 PLUS MINUS BULK
.ENDS
***************************************
.SUBCKT moscap_rf33_nw PLUS MINUS BULK
.ENDS
***************************************
.SUBCKT moscap_rf_nw PLUS MINUS BULK
.ENDS
***************************************
.SUBCKT nmos_rf D G S B
.ENDS
***************************************
.SUBCKT nmos_rf33 D G S B
.ENDS
***************************************
.SUBCKT nmos_rf33_6t D G S B NG PG
.ENDS
***************************************
.SUBCKT nmos_rf_6t D G S B NG PG
.ENDS
***************************************
.SUBCKT nmoscap PLUS MINUS
.ENDS
***************************************
.SUBCKT nmoscap_33 PLUS MINUS
.ENDS
***************************************
.SUBCKT pmos_rf D G S B
.ENDS
***************************************
.SUBCKT pmos_rf33 D G S B
.ENDS
***************************************
.SUBCKT pmos_rf33_5t D G S B PG
.ENDS
***************************************
.SUBCKT pmos_rf33_nw D G S B
.ENDS
***************************************
.SUBCKT pmos_rf33_nw_5t D G S B PG
.ENDS
***************************************
.SUBCKT pmos_rf_5t D G S B PG
.ENDS
***************************************
.SUBCKT pmos_rf_nw D G S B
.ENDS
***************************************
.SUBCKT pmos_rf_nw_5t D G S B PG
.ENDS
***************************************
.SUBCKT rnod_m PLUS MINUS B
.ENDS
***************************************
.SUBCKT rnodrpo_m PLUS MINUS B
.ENDS
***************************************
.SUBCKT rnodw_m PLUS MINUS B
.ENDS
***************************************
.SUBCKT rnpo1_dis PLUS MINUS B
.ENDS
***************************************
.SUBCKT rnpo1rpo_dis PLUS MINUS B
.ENDS
***************************************
.SUBCKT rnpo1w_dis PLUS MINUS B
.ENDS
***************************************
.SUBCKT rnwod_m PLUS MINUS B
.ENDS
***************************************
.SUBCKT rnwsti_m PLUS MINUS B
.ENDS
***************************************
.SUBCKT rpod_m PLUS MINUS B
.ENDS
***************************************
.SUBCKT rpodrpo_m PLUS MINUS B
.ENDS
***************************************
.SUBCKT rpodw_m PLUS MINUS B
.ENDS
***************************************
.SUBCKT rppo1_dis PLUS MINUS B
.ENDS
***************************************
.SUBCKT rppo1rpo_dis PLUS MINUS B
.ENDS
***************************************
.SUBCKT rppo1w_dis PLUS MINUS B
.ENDS
***************************************
.SUBCKT rppolyhri_dis PLUS MINUS B
.ENDS
***************************************
.SUBCKT rppolyhri_rf PLUS MINUS BULK
.ENDS
***************************************
.SUBCKT rppolyl_rf PLUS MINUS BULK
.ENDS
***************************************
.SUBCKT rppolys_rf PLUS MINUS BULK
.ENDS
***************************************
.SUBCKT rppolywo_rf PLUS MINUS BULK
.ENDS
***************************************
.SUBCKT sbd_rf PLUS MINUS BULK
.ENDS
***************************************
.SUBCKT sbd_rf_nw PLUS MINUS BULK
.ENDS
***************************************
.SUBCKT spiral_std_mu_x_40k PLUS MINUS BULK
.ENDS
***************************************
.SUBCKT spiral_sym_ct_mu_x_40k PLUS MINUS BULK CTAP
.ENDS
***************************************
.SUBCKT spiral_sym_mu_x_40k PLUS MINUS BULK
.ENDS
***************************************
.SUBCKT xjvar_nr36 PLUS MINUS BULK
.ENDS
***************************************
.SUBCKT xjvar_w40 PLUS MINUS BULK
.ENDS
***************************************
.SUBCKT PFILLER0005A
** N=5 EP=0 IP=0 FDC=0
.ENDS
***************************************
.SUBCKT ICV_1
** N=5 EP=0 IP=10 FDC=0
.ENDS
***************************************
.SUBCKT ICV_2
** N=5 EP=0 IP=10 FDC=0
.ENDS
***************************************
.SUBCKT ICV_3
** N=5 EP=0 IP=10 FDC=0
.ENDS
***************************************
.SUBCKT ICV_4
** N=5 EP=0 IP=10 FDC=0
.ENDS
***************************************
.SUBCKT SAB258_PFILLER0005_BASEA
** N=5 EP=0 IP=0 FDC=0
.ENDS
***************************************
.SUBCKT ICV_5
** N=5 EP=0 IP=10 FDC=0
.ENDS
***************************************
.SUBCKT ICV_6
** N=5 EP=0 IP=10 FDC=0
.ENDS
***************************************
.SUBCKT ICV_7
** N=5 EP=0 IP=10 FDC=0
.ENDS
***************************************
.SUBCKT ICV_8
** N=5 EP=0 IP=10 FDC=0
.ENDS
***************************************
.SUBCKT ICV_9
** N=5 EP=0 IP=10 FDC=0
.ENDS
***************************************
.SUBCKT PFILLER05A
** N=5 EP=0 IP=20 FDC=0
.ENDS
***************************************
.SUBCKT PFILLER1A
** N=5 EP=0 IP=0 FDC=0
.ENDS
***************************************
.SUBCKT SAB258_PFILLER5_BASEA
** N=5 EP=0 IP=0 FDC=0
.ENDS
***************************************
.SUBCKT PFILLER7p765A
** N=5 EP=0 IP=45 FDC=0
.ENDS
***************************************
.SUBCKT PFILLER20A
** N=5 EP=0 IP=20 FDC=0
.ENDS
***************************************
.SUBCKT PFILLER22p76A
** N=5 EP=0 IP=40 FDC=0
.ENDS
***************************************
.SUBCKT SAB258_PDIO_FILLER10
** N=2 EP=0 IP=0 FDC=0
.ENDS
***************************************
.SUBCKT SAB258_FILL_BODY
** N=4 EP=0 IP=18 FDC=0
.ENDS
***************************************
.SUBCKT SAB258_NDIO_STI 1 2
** N=3 EP=2 IP=0 FDC=1
D0 1 2 DN AREA=2e-11 PJ=2.4e-05 $X=5000 $Y=3030 $D=26
.ENDS
***************************************
.SUBCKT SAB258_PDIO_STI 1 2
** N=4 EP=2 IP=0 FDC=1
D0 1 2 DP AREA=2e-11 PJ=2.4e-05 $X=5000 $Y=3030 $D=27
.ENDS
***************************************
.SUBCKT SAB258_DIO_BODY 1 2 3
** N=5 EP=3 IP=31 FDC=9
X0 1 1 SAB258_NDIO_STI $T=20 41330 0 0 $X=-160 $Y=41150
X1 1 1 SAB258_NDIO_STI $T=20 49390 0 0 $X=-160 $Y=49210
X2 1 3 SAB258_NDIO_STI $T=20 57450 0 0 $X=-160 $Y=57270
X3 1 3 SAB258_NDIO_STI $T=20 65510 0 0 $X=-160 $Y=65330
X4 1 3 SAB258_NDIO_STI $T=20 73570 0 0 $X=-160 $Y=73390
X5 3 2 SAB258_PDIO_STI $T=20 3160 0 0 $X=720 $Y=2910
X6 3 2 SAB258_PDIO_STI $T=20 11220 0 0 $X=720 $Y=10970
X7 3 2 SAB258_PDIO_STI $T=20 19280 0 0 $X=720 $Y=19030
X8 2 2 SAB258_PDIO_STI $T=20 27340 0 0 $X=720 $Y=27090
.ENDS
***************************************
.SUBCKT M_PDB3AC_w_bond_and_schematic VSS TACVDD AIO
** N=6 EP=3 IP=16 FDC=18
X2 VSS TACVDD AIO SAB258_DIO_BODY $T=9980 0 0 0 $X=9820 $Y=0
X3 VSS TACVDD AIO SAB258_DIO_BODY $T=29980 0 0 0 $X=29820 $Y=0
.ENDS
***************************************
.SUBCKT PFILLER22p765A
** N=5 EP=0 IP=45 FDC=0
.ENDS
***************************************
.SUBCKT ICV_10 1 2 3
*.CALIBRE ICV_CELL 9
** N=8 EP=3 IP=11 FDC=18
X0 1 2 3 M_PDB3AC_w_bond_and_schematic $T=0 0 0 0 $X=-400 $Y=0
.ENDS
***************************************
.SUBCKT SAB258_CORNERA_VIA_D
** N=2 EP=0 IP=0 FDC=0
.ENDS
***************************************
.SUBCKT PCORNERA
** N=5 EP=0 IP=4 FDC=0
*.CALIBRE ISOLATED NETS: VSS TAVDD
.ENDS
***************************************
.SUBCKT SAB258_NEDGE_VD3AC_1
** N=2 EP=0 IP=0 FDC=0
.ENDS
***************************************
.SUBCKT SAB258_NDIOVSS2CDG_AC_1
** N=2 EP=0 IP=0 FDC=0
.ENDS
***************************************
.SUBCKT ICV_11
** N=2 EP=0 IP=4 FDC=0
.ENDS
***************************************
.SUBCKT SAB258_PINV04X20_AC_1
** N=4 EP=0 IP=0 FDC=0
.ENDS
***************************************
.SUBCKT ICV_12
** N=4 EP=0 IP=8 FDC=0
.ENDS
***************************************
.SUBCKT ICV_13
** N=4 EP=0 IP=8 FDC=0
.ENDS
***************************************
.SUBCKT SAB258_NMOS19D4X0D18_152_TMY849_C2 1 2 3
** N=3 EP=3 IP=0 FDC=2
M0 3 1 2 2 N L=1.8e-07 W=3.1e-05 $X=700 $Y=-10280 $D=0
M1 2 1 3 2 N L=1.8e-07 W=3.1e-05 $X=1820 $Y=-10280 $D=0
.ENDS
***************************************
.SUBCKT ICV_14 1 2 3
*.CALIBRE ICV_CELL 9
** N=3 EP=3 IP=6 FDC=4
X0 1 2 3 SAB258_NMOS19D4X0D18_152_TMY849_C2 $T=0 0 0 0 $X=-80 $Y=-11810
X1 1 2 3 SAB258_NMOS19D4X0D18_152_TMY849_C2 $T=1920 0 0 0 $X=1840 $Y=-11810
.ENDS
***************************************
.SUBCKT SAB258_NINV01X20_AC_1
** N=4 EP=0 IP=0 FDC=0
.ENDS
***************************************
.SUBCKT ICV_15
** N=3 EP=0 IP=8 FDC=0
.ENDS
***************************************
.SUBCKT ICV_16 1 3 4
*.CALIBRE ICV_CELL 9
** N=4 EP=3 IP=12 FDC=8
X0 1 3 4 ICV_14 $T=-180 -21690 0 0 $X=-260 $Y=-33500
X1 1 3 4 ICV_14 $T=3660 -21690 0 0 $X=3580 $Y=-33500
.ENDS
***************************************
.SUBCKT ICV_17
** N=2 EP=0 IP=4 FDC=0
.ENDS
***************************************
.SUBCKT ICV_18
** N=4 EP=0 IP=8 FDC=0
.ENDS
***************************************
.SUBCKT ICV_19 1 3 4
*.CALIBRE ICV_CELL 9
** N=4 EP=3 IP=8 FDC=16
X0 1 3 4 ICV_16 $T=0 0 0 0 $X=-260 $Y=-33500
X1 1 3 4 ICV_16 $T=7680 0 0 0 $X=7420 $Y=-33500
.ENDS
***************************************
.SUBCKT SAB258_LINK_LINE1_AC
** N=4 EP=0 IP=0 FDC=0
.ENDS
***************************************
.SUBCKT M_PVDD3AC_w_bond_and_schematic AVDD VSS 3
** N=9 EP=3 IP=48 FDC=129
M0 VSS 8 VSS VSS ND L=3.3e-06 W=4.59e-06 $X=3390 $Y=42610 $D=5
M1 7 8 VSS VSS ND L=4e-07 W=1e-06 $X=3880 $Y=47820 $D=5
M2 VSS 8 7 VSS ND L=4e-07 W=1e-06 $X=5800 $Y=47820 $D=5
M3 VSS 8 VSS VSS ND L=3.3e-06 W=4.59e-06 $X=7230 $Y=42610 $D=5
M4 7 8 VSS VSS ND L=4e-07 W=1e-06 $X=7720 $Y=47820 $D=5
M5 VSS 8 7 VSS ND L=4e-07 W=1e-06 $X=9640 $Y=47820 $D=5
M6 VSS 8 VSS VSS ND L=3.3e-06 W=4.59e-06 $X=11070 $Y=42610 $D=5
M7 7 8 VSS VSS ND L=4e-07 W=1e-06 $X=11560 $Y=47820 $D=5
M8 VSS 8 7 VSS ND L=4e-07 W=1e-06 $X=13480 $Y=47820 $D=5
M9 VSS 8 VSS VSS ND L=3.3e-06 W=4.59e-06 $X=14910 $Y=42610 $D=5
M10 7 8 VSS VSS ND L=4e-07 W=1e-06 $X=15400 $Y=47820 $D=5
M11 VSS 8 7 VSS ND L=4e-07 W=1e-06 $X=17320 $Y=47820 $D=5
M12 VSS 8 VSS VSS ND L=3.3e-06 W=4.59e-06 $X=18750 $Y=42610 $D=5
M13 7 8 VSS VSS ND L=4e-07 W=1e-06 $X=19240 $Y=47820 $D=5
M14 VSS 8 7 VSS ND L=4e-07 W=1e-06 $X=21160 $Y=47820 $D=5
M15 VSS 8 VSS VSS ND L=3.3e-06 W=4.59e-06 $X=22590 $Y=42610 $D=5
M16 7 8 VSS VSS ND L=4e-07 W=1e-06 $X=23080 $Y=47820 $D=5
M17 VSS 8 7 VSS ND L=4e-07 W=1e-06 $X=25000 $Y=47820 $D=5
M18 VSS 8 VSS VSS ND L=3.3e-06 W=4.59e-06 $X=26430 $Y=42610 $D=5
M19 7 8 VSS VSS ND L=4e-07 W=1e-06 $X=26920 $Y=47820 $D=5
M20 VSS 8 7 VSS ND L=4e-07 W=1e-06 $X=28840 $Y=47820 $D=5
M21 VSS 8 VSS VSS ND L=3.3e-06 W=4.59e-06 $X=30270 $Y=42610 $D=5
M22 7 8 VSS VSS ND L=4e-07 W=1e-06 $X=30760 $Y=47820 $D=5
M23 VSS 8 7 VSS ND L=4e-07 W=1e-06 $X=32680 $Y=47820 $D=5
M24 VSS 8 VSS VSS ND L=3.3e-06 W=4.59e-06 $X=34110 $Y=42610 $D=5
M25 7 8 VSS VSS ND L=4e-07 W=1e-06 $X=34600 $Y=47820 $D=5
M26 VSS 8 7 VSS ND L=4e-07 W=1e-06 $X=36520 $Y=47820 $D=5
M27 VSS 8 VSS VSS ND L=3.3e-06 W=4.59e-06 $X=37950 $Y=42610 $D=5
M28 7 8 VSS VSS ND L=4e-07 W=1e-06 $X=38440 $Y=47820 $D=5
M29 VSS 8 7 VSS ND L=4e-07 W=1e-06 $X=40360 $Y=47820 $D=5
M30 VSS 8 VSS VSS ND L=3.3e-06 W=4.59e-06 $X=41790 $Y=42610 $D=5
M31 7 8 VSS VSS ND L=4e-07 W=1e-06 $X=42280 $Y=47820 $D=5
M32 VSS 8 7 VSS ND L=4e-07 W=1e-06 $X=44200 $Y=47820 $D=5
M33 VSS 8 VSS VSS ND L=3.3e-06 W=4.59e-06 $X=45630 $Y=42610 $D=5
M34 7 8 VSS VSS ND L=4e-07 W=1e-06 $X=46120 $Y=47820 $D=5
M35 VSS 8 7 VSS ND L=4e-07 W=1e-06 $X=48040 $Y=47820 $D=5
M36 VSS 8 VSS VSS ND L=3.3e-06 W=4.59e-06 $X=49470 $Y=42610 $D=5
M37 7 8 VSS VSS ND L=4e-07 W=1e-06 $X=49960 $Y=47820 $D=5
M38 VSS 8 7 VSS ND L=4e-07 W=1e-06 $X=51880 $Y=47820 $D=5
M39 VSS 8 VSS VSS ND L=3.3e-06 W=4.59e-06 $X=53310 $Y=42610 $D=5
M40 7 8 VSS VSS ND L=4e-07 W=1e-06 $X=53800 $Y=47820 $D=5
M41 VSS 8 7 VSS ND L=4e-07 W=1e-06 $X=55720 $Y=47820 $D=5
M42 7 8 AVDD AVDD PD L=4e-07 W=4e-06 $X=3880 $Y=30645 $D=18
M43 AVDD 8 7 AVDD PD L=4e-07 W=4e-06 $X=5800 $Y=30645 $D=18
M44 7 8 AVDD AVDD PD L=4e-07 W=4e-06 $X=7720 $Y=30645 $D=18
M45 AVDD 8 7 AVDD PD L=4e-07 W=4e-06 $X=9640 $Y=30645 $D=18
M46 7 8 AVDD AVDD PD L=4e-07 W=4e-06 $X=11560 $Y=30645 $D=18
M47 AVDD 8 7 AVDD PD L=4e-07 W=4e-06 $X=13480 $Y=30645 $D=18
M48 7 8 AVDD AVDD PD L=4e-07 W=4e-06 $X=15400 $Y=30645 $D=18
M49 AVDD 8 7 AVDD PD L=4e-07 W=4e-06 $X=17320 $Y=30645 $D=18
M50 7 8 AVDD AVDD PD L=4e-07 W=4e-06 $X=19240 $Y=30645 $D=18
M51 AVDD 8 7 AVDD PD L=4e-07 W=4e-06 $X=21160 $Y=30645 $D=18
M52 7 8 AVDD AVDD PD L=4e-07 W=4e-06 $X=23080 $Y=30645 $D=18
M53 AVDD 8 7 AVDD PD L=4e-07 W=4e-06 $X=25000 $Y=30645 $D=18
M54 7 8 AVDD AVDD PD L=4e-07 W=4e-06 $X=26920 $Y=30645 $D=18
M55 AVDD 8 7 AVDD PD L=4e-07 W=4e-06 $X=28840 $Y=30645 $D=18
M56 7 8 AVDD AVDD PD L=4e-07 W=4e-06 $X=30760 $Y=30645 $D=18
M57 AVDD 8 7 AVDD PD L=4e-07 W=4e-06 $X=32680 $Y=30645 $D=18
M58 7 8 AVDD AVDD PD L=4e-07 W=4e-06 $X=34600 $Y=30645 $D=18
M59 AVDD 8 7 AVDD PD L=4e-07 W=4e-06 $X=36520 $Y=30645 $D=18
M60 7 8 AVDD AVDD PD L=4e-07 W=4e-06 $X=38440 $Y=30645 $D=18
M61 AVDD 8 7 AVDD PD L=4e-07 W=4e-06 $X=40360 $Y=30645 $D=18
M62 7 8 AVDD AVDD PD L=4e-07 W=4e-06 $X=42280 $Y=30645 $D=18
M63 AVDD 8 7 AVDD PD L=4e-07 W=4e-06 $X=44200 $Y=30645 $D=18
M64 7 8 AVDD AVDD PD L=4e-07 W=4e-06 $X=46120 $Y=30645 $D=18
M65 AVDD 8 7 AVDD PD L=4e-07 W=4e-06 $X=48040 $Y=30645 $D=18
M66 7 8 AVDD AVDD PD L=4e-07 W=4e-06 $X=49960 $Y=30645 $D=18
M67 AVDD 8 7 AVDD PD L=4e-07 W=4e-06 $X=51880 $Y=30645 $D=18
M68 7 8 AVDD AVDD PD L=4e-07 W=4e-06 $X=53800 $Y=30645 $D=18
M69 AVDD 8 7 AVDD PD L=4e-07 W=4e-06 $X=55720 $Y=30645 $D=18
R70 AVDD 3 0.000142232 $[M1] $X=2580 $Y=82900 $D=33
R71 AVDD 3 0.000142232 $[M2] $X=2580 $Y=82900 $D=34
R72 AVDD 8 2.79552e+06 $[PR] $X=1170 $Y=2355 $D=47
X77 7 VSS AVDD ICV_16 $T=48990 48920 1 0 $X=48730 $Y=47300
X84 7 VSS AVDD ICV_19 $T=2910 48920 1 0 $X=2650 $Y=47300
X85 7 VSS AVDD ICV_19 $T=18270 48920 1 0 $X=18010 $Y=47300
X86 7 VSS AVDD ICV_19 $T=33630 48920 1 0 $X=33370 $Y=47300
.ENDS
***************************************
.SUBCKT SAB258_PINV04X20_AC
** N=4 EP=0 IP=0 FDC=0
.ENDS
***************************************
.SUBCKT ICV_20
** N=4 EP=0 IP=8 FDC=0
.ENDS
***************************************
.SUBCKT ICV_21
** N=4 EP=0 IP=8 FDC=0
.ENDS
***************************************
.SUBCKT ICV_22
** N=4 EP=0 IP=8 FDC=0
.ENDS
***************************************
.SUBCKT SAB258_NDIOVSS2CDG_AC
** N=2 EP=0 IP=0 FDC=0
.ENDS
***************************************
.SUBCKT ICV_23
** N=2 EP=0 IP=4 FDC=0
.ENDS
***************************************
.SUBCKT ICV_24
** N=2 EP=0 IP=4 FDC=0
.ENDS
***************************************
.SUBCKT SAB258_NMOS19D4X0D18_CLA 1 2 3
** N=3 EP=3 IP=0 FDC=2
M0 3 1 2 2 N L=1.8e-07 W=3.1e-05 $X=700 $Y=-10280 $D=0
M1 2 1 3 2 N L=1.8e-07 W=3.1e-05 $X=1820 $Y=-10280 $D=0
.ENDS
***************************************
.SUBCKT ICV_25 1 2 3
*.CALIBRE ICV_CELL 9
** N=3 EP=3 IP=6 FDC=4
X0 1 2 3 SAB258_NMOS19D4X0D18_CLA $T=0 0 0 0 $X=-80 $Y=-11280
X1 1 2 3 SAB258_NMOS19D4X0D18_CLA $T=1920 0 0 0 $X=1840 $Y=-11280
.ENDS
***************************************
.SUBCKT SAB258_NINV01X20_AC
** N=4 EP=0 IP=0 FDC=0
.ENDS
***************************************
.SUBCKT ICV_26
** N=3 EP=0 IP=8 FDC=0
.ENDS
***************************************
.SUBCKT ICV_27 1 3 4
*.CALIBRE ICV_CELL 9
** N=4 EP=3 IP=12 FDC=8
X0 1 3 4 ICV_25 $T=0 0 0 0 $X=-80 $Y=-11280
X1 1 3 4 ICV_25 $T=3840 0 0 0 $X=3760 $Y=-11280
.ENDS
***************************************
.SUBCKT ICV_28 1 3 4
*.CALIBRE ICV_CELL 9
** N=4 EP=3 IP=8 FDC=16
X0 1 3 4 ICV_27 $T=0 0 0 0 $X=-80 $Y=-11280
X1 1 3 4 ICV_27 $T=7680 0 0 0 $X=7600 $Y=-11280
.ENDS
***************************************
.SUBCKT SAB258_NEDGE_VD3AC
** N=2 EP=0 IP=0 FDC=0
.ENDS
***************************************
.SUBCKT PCLAMPAC_w_schematic AVDD AVSS
** N=6 EP=2 IP=44 FDC=127
M0 3 4 AVSS AVSS ND L=4e-07 W=1e-06 $X=35570 $Y=6380 $D=5
M1 AVSS 4 3 AVSS ND L=4e-07 W=1e-06 $X=35570 $Y=8300 $D=5
M2 3 4 AVSS AVSS ND L=4e-07 W=1e-06 $X=35570 $Y=10220 $D=5
M3 AVSS 4 3 AVSS ND L=4e-07 W=1e-06 $X=35570 $Y=12140 $D=5
M4 3 4 AVSS AVSS ND L=4e-07 W=1e-06 $X=35570 $Y=14060 $D=5
M5 AVSS 4 3 AVSS ND L=4e-07 W=1e-06 $X=35570 $Y=15980 $D=5
M6 3 4 AVSS AVSS ND L=4e-07 W=1e-06 $X=35570 $Y=17900 $D=5
M7 AVSS 4 3 AVSS ND L=4e-07 W=1e-06 $X=35570 $Y=19820 $D=5
M8 3 4 AVSS AVSS ND L=4e-07 W=1e-06 $X=35570 $Y=21740 $D=5
M9 AVSS 4 3 AVSS ND L=4e-07 W=1e-06 $X=35570 $Y=23660 $D=5
M10 3 4 AVSS AVSS ND L=4e-07 W=1e-06 $X=35570 $Y=25580 $D=5
M11 AVSS 4 3 AVSS ND L=4e-07 W=1e-06 $X=35570 $Y=27500 $D=5
M12 3 4 AVSS AVSS ND L=4e-07 W=1e-06 $X=35570 $Y=29420 $D=5
M13 AVSS 4 3 AVSS ND L=4e-07 W=1e-06 $X=35570 $Y=31340 $D=5
M14 3 4 AVSS AVSS ND L=4e-07 W=1e-06 $X=35570 $Y=33260 $D=5
M15 AVSS 4 3 AVSS ND L=4e-07 W=1e-06 $X=35570 $Y=35180 $D=5
M16 3 4 AVSS AVSS ND L=4e-07 W=1e-06 $X=35570 $Y=37100 $D=5
M17 AVSS 4 3 AVSS ND L=4e-07 W=1e-06 $X=35570 $Y=39020 $D=5
M18 3 4 AVSS AVSS ND L=4e-07 W=1e-06 $X=35570 $Y=40940 $D=5
M19 AVSS 4 3 AVSS ND L=4e-07 W=1e-06 $X=35570 $Y=42860 $D=5
M20 3 4 AVSS AVSS ND L=4e-07 W=1e-06 $X=35570 $Y=44780 $D=5
M21 AVSS 4 3 AVSS ND L=4e-07 W=1e-06 $X=35570 $Y=46700 $D=5
M22 3 4 AVSS AVSS ND L=4e-07 W=1e-06 $X=35570 $Y=48620 $D=5
M23 AVSS 4 3 AVSS ND L=4e-07 W=1e-06 $X=35570 $Y=50540 $D=5
M24 3 4 AVSS AVSS ND L=4e-07 W=1e-06 $X=35570 $Y=52460 $D=5
M25 AVSS 4 3 AVSS ND L=4e-07 W=1e-06 $X=35570 $Y=54380 $D=5
M26 3 4 AVSS AVSS ND L=4e-07 W=1e-06 $X=35570 $Y=56300 $D=5
M27 AVSS 4 3 AVSS ND L=4e-07 W=1e-06 $X=35570 $Y=58220 $D=5
M28 AVSS 4 AVSS AVSS ND L=3.3e-06 W=4.59e-06 $X=37190 $Y=5890 $D=5
M29 AVSS 4 AVSS AVSS ND L=3.3e-06 W=4.59e-06 $X=37190 $Y=9730 $D=5
M30 AVSS 4 AVSS AVSS ND L=3.3e-06 W=4.59e-06 $X=37190 $Y=13570 $D=5
M31 AVSS 4 AVSS AVSS ND L=3.3e-06 W=4.59e-06 $X=37190 $Y=17410 $D=5
M32 AVSS 4 AVSS AVSS ND L=3.3e-06 W=4.59e-06 $X=37190 $Y=21250 $D=5
M33 AVSS 4 AVSS AVSS ND L=3.3e-06 W=4.59e-06 $X=37190 $Y=25090 $D=5
M34 AVSS 4 AVSS AVSS ND L=3.3e-06 W=4.59e-06 $X=37190 $Y=28930 $D=5
M35 AVSS 4 AVSS AVSS ND L=3.3e-06 W=4.59e-06 $X=37190 $Y=32770 $D=5
M36 AVSS 4 AVSS AVSS ND L=3.3e-06 W=4.59e-06 $X=37190 $Y=36610 $D=5
M37 AVSS 4 AVSS AVSS ND L=3.3e-06 W=4.59e-06 $X=37190 $Y=40450 $D=5
M38 AVSS 4 AVSS AVSS ND L=3.3e-06 W=4.59e-06 $X=37190 $Y=44290 $D=5
M39 AVSS 4 AVSS AVSS ND L=3.3e-06 W=4.59e-06 $X=37190 $Y=48130 $D=5
M40 AVSS 4 AVSS AVSS ND L=3.3e-06 W=4.59e-06 $X=37190 $Y=51970 $D=5
M41 AVSS 4 AVSS AVSS ND L=3.3e-06 W=4.59e-06 $X=37190 $Y=55810 $D=5
M42 3 4 AVDD AVDD PD L=4e-07 W=4e-06 $X=45445 $Y=6380 $D=18
M43 AVDD 4 3 AVDD PD L=4e-07 W=4e-06 $X=45445 $Y=8300 $D=18
M44 3 4 AVDD AVDD PD L=4e-07 W=4e-06 $X=45445 $Y=10220 $D=18
M45 AVDD 4 3 AVDD PD L=4e-07 W=4e-06 $X=45445 $Y=12140 $D=18
M46 3 4 AVDD AVDD PD L=4e-07 W=4e-06 $X=45445 $Y=14060 $D=18
M47 AVDD 4 3 AVDD PD L=4e-07 W=4e-06 $X=45445 $Y=15980 $D=18
M48 3 4 AVDD AVDD PD L=4e-07 W=4e-06 $X=45445 $Y=17900 $D=18
M49 AVDD 4 3 AVDD PD L=4e-07 W=4e-06 $X=45445 $Y=19820 $D=18
M50 3 4 AVDD AVDD PD L=4e-07 W=4e-06 $X=45445 $Y=21740 $D=18
M51 AVDD 4 3 AVDD PD L=4e-07 W=4e-06 $X=45445 $Y=23660 $D=18
M52 3 4 AVDD AVDD PD L=4e-07 W=4e-06 $X=45445 $Y=25580 $D=18
M53 AVDD 4 3 AVDD PD L=4e-07 W=4e-06 $X=45445 $Y=27500 $D=18
M54 3 4 AVDD AVDD PD L=4e-07 W=4e-06 $X=45445 $Y=29420 $D=18
M55 AVDD 4 3 AVDD PD L=4e-07 W=4e-06 $X=45445 $Y=31340 $D=18
M56 3 4 AVDD AVDD PD L=4e-07 W=4e-06 $X=45445 $Y=33260 $D=18
M57 AVDD 4 3 AVDD PD L=4e-07 W=4e-06 $X=45445 $Y=35180 $D=18
M58 3 4 AVDD AVDD PD L=4e-07 W=4e-06 $X=45445 $Y=37100 $D=18
M59 AVDD 4 3 AVDD PD L=4e-07 W=4e-06 $X=45445 $Y=39020 $D=18
M60 3 4 AVDD AVDD PD L=4e-07 W=4e-06 $X=45445 $Y=40940 $D=18
M61 AVDD 4 3 AVDD PD L=4e-07 W=4e-06 $X=45445 $Y=42860 $D=18
M62 3 4 AVDD AVDD PD L=4e-07 W=4e-06 $X=45445 $Y=44780 $D=18
M63 AVDD 4 3 AVDD PD L=4e-07 W=4e-06 $X=45445 $Y=46700 $D=18
M64 3 4 AVDD AVDD PD L=4e-07 W=4e-06 $X=45445 $Y=48620 $D=18
M65 AVDD 4 3 AVDD PD L=4e-07 W=4e-06 $X=45445 $Y=50540 $D=18
M66 3 4 AVDD AVDD PD L=4e-07 W=4e-06 $X=45445 $Y=52460 $D=18
M67 AVDD 4 3 AVDD PD L=4e-07 W=4e-06 $X=45445 $Y=54380 $D=18
M68 3 4 AVDD AVDD PD L=4e-07 W=4e-06 $X=45445 $Y=56300 $D=18
M69 AVDD 4 3 AVDD PD L=4e-07 W=4e-06 $X=45445 $Y=58220 $D=18
R70 4 AVDD 2.79552e+06 $[PR] $X=52795 $Y=61030 $D=47
X79 3 AVSS AVDD ICV_27 $T=13780 51310 1 90 $X=2500 $Y=51230
X80 3 AVSS AVDD ICV_28 $T=13780 5230 1 90 $X=2500 $Y=5150
X81 3 AVSS AVDD ICV_28 $T=13780 20590 1 90 $X=2500 $Y=20510
X82 3 AVSS AVDD ICV_28 $T=13780 35950 1 90 $X=2500 $Y=35870
.ENDS
***************************************
.SUBCKT SAB258_NEDGE_PVDD2DGZ_1
** N=2 EP=0 IP=0 FDC=0
.ENDS
***************************************
.SUBCKT SAB258_VS3A_CON1
** N=2 EP=0 IP=0 FDC=0
.ENDS
***************************************
.SUBCKT SAB258_VS3A_CON2
** N=1 EP=0 IP=0 FDC=0
.ENDS
***************************************
.SUBCKT SAB258_NDIOVSS2ANA_TMY849_C2 1
** N=2 EP=1 IP=0 FDC=1
D0 1 1 DN AREA=4.66088e-11 PJ=3.498e-05 $X=1240 $Y=2280 $D=26
.ENDS
***************************************
.SUBCKT SAB258_PDIOVSS2ANA_TMY849_C2 1
** N=2 EP=1 IP=0 FDC=1
D0 1 1 DP AREA=4.66088e-11 PJ=3.498e-05 $X=1240 $Y=2280 $D=27
.ENDS
***************************************
.SUBCKT SAB258_PDIO_1 1 2
** N=3 EP=2 IP=0 FDC=1
D0 1 2 DP AREA=9.31028e-11 PJ=6.333e-05 $X=2020 $Y=-2130 $D=27
.ENDS
***************************************
.SUBCKT ICV_29 1
*.CALIBRE ICV_CELL 9
** N=3 EP=1 IP=4 FDC=2
X0 1 SAB258_NDIOVSS2ANA_TMY849_C2 $T=0 0 0 0 $X=-20 $Y=-2520
X1 1 SAB258_NDIOVSS2ANA_TMY849_C2 $T=4800 0 0 0 $X=4780 $Y=-2520
.ENDS
***************************************
.SUBCKT ICV_30 1
*.CALIBRE ICV_CELL 9
** N=2 EP=1 IP=4 FDC=2
X0 1 SAB258_PDIOVSS2ANA_TMY849_C2 $T=0 0 0 0 $X=-180 $Y=-200
X1 1 SAB258_PDIOVSS2ANA_TMY849_C2 $T=4800 0 0 0 $X=4620 $Y=-200
.ENDS
***************************************
.SUBCKT ICV_31 1 2
*.CALIBRE ICV_CELL 9
** N=3 EP=2 IP=6 FDC=2
X0 2 1 SAB258_PDIO_1 $T=0 0 0 0 $X=380 $Y=-5160
X1 2 1 SAB258_PDIO_1 $T=4800 0 0 0 $X=5180 $Y=-5160
.ENDS
***************************************
.SUBCKT M_PVSS2AC_w_bond_and_schematic VSS TACVDD
** N=26 EP=2 IP=69 FDC=33
X14 VSS SAB258_NDIOVSS2ANA_TMY849_C2 $T=51120 41330 0 0 $X=51100 $Y=38810
X15 VSS SAB258_PDIOVSS2ANA_TMY849_C2 $T=51120 61400 0 0 $X=50940 $Y=61200
X16 VSS TACVDD SAB258_PDIO_1 $T=50340 7160 0 0 $X=50720 $Y=2000
X17 VSS ICV_29 $T=3120 41330 0 0 $X=3100 $Y=38810
X18 VSS ICV_29 $T=12720 41330 0 0 $X=12700 $Y=38810
X19 VSS ICV_29 $T=22320 41330 0 0 $X=22300 $Y=38810
X20 VSS ICV_29 $T=31920 41330 0 0 $X=31900 $Y=38810
X21 VSS ICV_29 $T=41520 41330 0 0 $X=41500 $Y=38810
X22 VSS ICV_30 $T=3120 61400 0 0 $X=2940 $Y=61200
X23 VSS ICV_30 $T=12720 61400 0 0 $X=12540 $Y=61200
X24 VSS ICV_30 $T=22320 61400 0 0 $X=22140 $Y=61200
X25 VSS ICV_30 $T=31920 61400 0 0 $X=31740 $Y=61200
X26 VSS ICV_30 $T=41520 61400 0 0 $X=41340 $Y=61200
X27 TACVDD VSS ICV_31 $T=2340 7160 0 0 $X=2720 $Y=2000
X28 TACVDD VSS ICV_31 $T=11940 7160 0 0 $X=12320 $Y=2000
X29 TACVDD VSS ICV_31 $T=21540 7160 0 0 $X=21920 $Y=2000
X30 TACVDD VSS ICV_31 $T=31140 7160 0 0 $X=31520 $Y=2000
X31 TACVDD VSS ICV_31 $T=40740 7160 0 0 $X=41120 $Y=2000
.ENDS
***************************************
.SUBCKT M_PVDD3VSS2AC_w_bond_and_schematic VSS AVDD
** N=6 EP=2 IP=18 FDC=289
X1 AVDD VSS 6 M_PVDD3AC_w_bond_and_schematic $T=0 0 0 0 $X=-400 $Y=0
X2 6 VSS PCLAMPAC_w_schematic $T=114285 85000 1 180 $X=34815 $Y=85000
X3 VSS AVDD M_PVSS2AC_w_bond_and_schematic $T=82765 0 0 0 $X=82365 $Y=0
.ENDS
***************************************
.SUBCKT ICV_32 1 2 3
*.CALIBRE ICV_CELL 9
** N=8 EP=3 IP=11 FDC=18
X0 1 2 3 M_PDB3AC_w_bond_and_schematic $T=-60000 0 0 0 $X=-60400 $Y=0
.ENDS
***************************************
.SUBCKT ICV_33 1 2 3
*.CALIBRE ICV_CELL 9
** N=9 EP=3 IP=12 FDC=36
X0 1 2 3 ICV_32 $T=-82765 0 0 0 $X=-143165 $Y=0
X1 1 2 7 ICV_32 $T=0 0 0 0 $X=-60400 $Y=0
.ENDS
***************************************
.SUBCKT ICV_34 1 2 3 4
*.CALIBRE ICV_CELL 9
** N=9 EP=4 IP=12 FDC=36
X0 1 2 3 ICV_10 $T=0 0 0 0 $X=-400 $Y=0
X1 1 2 4 ICV_10 $T=82765 0 0 0 $X=82365 $Y=0
.ENDS
***************************************
.SUBCKT FILL2BWP7T
** N=6 EP=0 IP=0 FDC=0
*.CALIBRE ISOLATED NETS: VSS VDD
.ENDS
***************************************
.SUBCKT FILL1BWP7T
** N=4 EP=0 IP=0 FDC=0
*.CALIBRE ISOLATED NETS: VSS VDD
.ENDS
***************************************
.SUBCKT ICV_35
** N=2 EP=0 IP=4 FDC=0
.ENDS
***************************************
.SUBCKT ICV_36
** N=2 EP=0 IP=4 FDC=0
.ENDS
***************************************
.SUBCKT ICV_37
** N=2 EP=0 IP=4 FDC=0
.ENDS
***************************************
.SUBCKT ICV_38
** N=2 EP=0 IP=4 FDC=0
.ENDS
***************************************
.SUBCKT ICV_39
** N=2 EP=0 IP=4 FDC=0
.ENDS
***************************************
.SUBCKT ICV_40
** N=2 EP=0 IP=4 FDC=0
.ENDS
***************************************
.SUBCKT FILL4BWP7T
** N=8 EP=0 IP=0 FDC=0
*.CALIBRE ISOLATED NETS: VSS VDD
.ENDS
***************************************
.SUBCKT ICV_41
** N=2 EP=0 IP=4 FDC=0
.ENDS
***************************************
.SUBCKT TAPCELLBWP7T
** N=4 EP=0 IP=0 FDC=0
*.CALIBRE ISOLATED NETS: VSS VDD
.ENDS
***************************************
.SUBCKT ICV_42
** N=2 EP=0 IP=4 FDC=0
.ENDS
***************************************
.SUBCKT ICV_43
** N=2 EP=0 IP=4 FDC=0
.ENDS
***************************************
.SUBCKT ICV_44
** N=2 EP=0 IP=4 FDC=0
.ENDS
***************************************
.SUBCKT ICV_45
** N=2 EP=0 IP=4 FDC=0
.ENDS
***************************************
.SUBCKT ICV_46
** N=2 EP=0 IP=4 FDC=0
.ENDS
***************************************
.SUBCKT ICV_47
** N=2 EP=0 IP=4 FDC=0
.ENDS
***************************************
.SUBCKT ICV_48
** N=2 EP=0 IP=4 FDC=0
.ENDS
***************************************
.SUBCKT ICV_49
** N=2 EP=0 IP=4 FDC=0
.ENDS
***************************************
.SUBCKT ICV_50
** N=2 EP=0 IP=4 FDC=0
.ENDS
***************************************
.SUBCKT ICV_51
** N=2 EP=0 IP=4 FDC=0
.ENDS
***************************************
.SUBCKT FILL8BWP7T
** N=12 EP=0 IP=0 FDC=0
*.CALIBRE ISOLATED NETS: VSS VDD
.ENDS
***************************************
.SUBCKT ICV_52
** N=2 EP=0 IP=4 FDC=0
.ENDS
***************************************
.SUBCKT ICV_53
** N=2 EP=0 IP=4 FDC=0
.ENDS
***************************************
.SUBCKT ICV_54
** N=2 EP=0 IP=4 FDC=0
.ENDS
***************************************
.SUBCKT FILL16BWP7T
** N=20 EP=0 IP=0 FDC=0
*.CALIBRE ISOLATED NETS: VSS VDD
.ENDS
***************************************
.SUBCKT ICV_55
** N=2 EP=0 IP=4 FDC=0
.ENDS
***************************************
.SUBCKT ICV_56
** N=2 EP=0 IP=4 FDC=0
.ENDS
***************************************
.SUBCKT ICV_57
** N=2 EP=0 IP=4 FDC=0
.ENDS
***************************************
.SUBCKT MUX2D1BWP7T I0 S I1 VDD Z VSS
** N=12 EP=6 IP=0 FDC=12
M0 VSS S 7 VSS N L=1.8e-07 W=5e-07 $X=635 $Y=345 $D=0
M1 11 I0 VSS VSS N L=1.8e-07 W=1e-06 $X=1395 $Y=345 $D=0
M2 8 7 11 VSS N L=1.8e-07 W=5e-07 $X=1995 $Y=345 $D=0
M3 12 S 8 VSS N L=1.8e-07 W=5e-07 $X=2740 $Y=345 $D=0
M4 VSS I1 12 VSS N L=1.8e-07 W=1e-06 $X=3440 $Y=345 $D=0
M5 Z 8 VSS VSS N L=1.8e-07 W=1e-06 $X=4240 $Y=345 $D=0
M6 VDD S 7 VDD P L=1.8e-07 W=6.85e-07 $X=635 $Y=2590 $D=16
M7 9 I0 VDD VDD P L=1.8e-07 W=9.4e-07 $X=1400 $Y=2205 $D=16
M8 8 S 9 VDD P L=1.8e-07 W=6.85e-07 $X=2020 $Y=2590 $D=16
M9 10 7 8 VDD P L=1.8e-07 W=6.85e-07 $X=2820 $Y=2590 $D=16
M10 VDD I1 10 VDD P L=1.8e-07 W=1.37e-06 $X=3440 $Y=2205 $D=16
M11 Z 8 VDD VDD P L=1.8e-07 W=1.37e-06 $X=4240 $Y=2205 $D=16
.ENDS
***************************************
.SUBCKT ICV_58
** N=2 EP=0 IP=4 FDC=0
.ENDS
***************************************
.SUBCKT INR2XD0BWP7T A1 B1 VDD ZN VSS
** N=7 EP=5 IP=0 FDC=6
M0 VSS A1 6 VSS N L=1.8e-07 W=5e-07 $X=620 $Y=500 $D=0
M1 ZN 6 VSS VSS N L=1.8e-07 W=5e-07 $X=1280 $Y=820 $D=0
M2 VSS B1 ZN VSS N L=1.8e-07 W=5e-07 $X=2000 $Y=820 $D=0
M3 VDD A1 6 VDD P L=1.8e-07 W=6.85e-07 $X=620 $Y=2890 $D=16
M4 7 6 VDD VDD P L=1.8e-07 W=1.37e-06 $X=1400 $Y=2205 $D=16
M5 ZN B1 7 VDD P L=1.8e-07 W=1.37e-06 $X=2000 $Y=2205 $D=16
.ENDS
***************************************
.SUBCKT ICV_59
** N=2 EP=0 IP=4 FDC=0
.ENDS
***************************************
.SUBCKT DFKCNQD1BWP7T CP CN D VDD Q VSS
** N=19 EP=6 IP=0 FDC=26
M0 VSS CP 10 VSS N L=1.8e-07 W=5e-07 $X=620 $Y=840 $D=0
M1 7 10 VSS VSS N L=1.8e-07 W=5e-07 $X=1425 $Y=840 $D=0
M2 16 CN VSS VSS N L=1.8e-07 W=9.7e-07 $X=2925 $Y=345 $D=0
M3 17 D 16 VSS N L=1.8e-07 W=9.7e-07 $X=3535 $Y=345 $D=0
M4 9 10 17 VSS N L=1.8e-07 W=9.7e-07 $X=4145 $Y=345 $D=0
M5 18 7 9 VSS N L=1.8e-07 W=4.2e-07 $X=5120 $Y=895 $D=0
M6 VSS 8 18 VSS N L=1.8e-07 W=4.2e-07 $X=5585 $Y=895 $D=0
M7 8 9 VSS VSS N L=1.8e-07 W=5.4e-07 $X=6385 $Y=775 $D=0
M8 12 7 8 VSS N L=1.8e-07 W=9.1e-07 $X=7105 $Y=405 $D=0
M9 19 10 12 VSS N L=1.8e-07 W=4.2e-07 $X=7845 $Y=895 $D=0
M10 VSS 11 19 VSS N L=1.8e-07 W=4.2e-07 $X=8375 $Y=895 $D=0
M11 11 12 VSS VSS N L=1.8e-07 W=1e-06 $X=8980 $Y=345 $D=0
M12 Q 11 VSS VSS N L=1.8e-07 W=1e-06 $X=10400 $Y=345 $D=0
M13 VDD CP 10 VDD P L=1.8e-07 W=6.85e-07 $X=620 $Y=2345 $D=16
M14 7 10 VDD VDD P L=1.8e-07 W=6.85e-07 $X=1220 $Y=2345 $D=16
M15 VDD CN 13 VDD P L=1.8e-07 W=4.2e-07 $X=2640 $Y=2315 $D=16
M16 13 D VDD VDD P L=1.8e-07 W=9.5e-07 $X=3440 $Y=2175 $D=16
M17 9 7 13 VDD P L=1.8e-07 W=6.5e-07 $X=4245 $Y=2175 $D=16
M18 14 10 9 VDD P L=1.8e-07 W=4.2e-07 $X=5155 $Y=2705 $D=16
M19 VDD 8 14 VDD P L=1.8e-07 W=4.2e-07 $X=5585 $Y=2705 $D=16
M20 8 9 VDD VDD P L=1.8e-07 W=9.6e-07 $X=6385 $Y=2175 $D=16
M21 12 10 8 VDD P L=1.8e-07 W=1.34e-06 $X=7105 $Y=2175 $D=16
M22 15 7 12 VDD P L=1.8e-07 W=4.2e-07 $X=7845 $Y=2470 $D=16
M23 VDD 11 15 VDD P L=1.8e-07 W=4.2e-07 $X=8380 $Y=2470 $D=16
M24 11 12 VDD VDD P L=1.8e-07 W=1.37e-06 $X=9140 $Y=2205 $D=16
M25 Q 11 VDD VDD P L=1.8e-07 W=1.37e-06 $X=10400 $Y=2205 $D=16
.ENDS
***************************************
.SUBCKT ICV_60 1 2 3 4 5 6
*.CALIBRE ICV_CELL 9
** N=6 EP=6 IP=8 FDC=26
X1 5 1 2 4 6 3 DFKCNQD1BWP7T $T=0 0 0 0 $X=-290 $Y=-235
.ENDS
***************************************
.SUBCKT NR2XD0BWP7T A2 A1 VDD ZN VSS
** N=7 EP=5 IP=0 FDC=4
M0 ZN A2 VSS VSS N L=1.8e-07 W=5e-07 $X=720 $Y=360 $D=0
M1 VSS A1 ZN VSS N L=1.8e-07 W=5e-07 $X=1440 $Y=360 $D=0
M2 6 A2 VDD VDD P L=1.8e-07 W=1.37e-06 $X=720 $Y=2205 $D=16
M3 ZN A1 6 VDD P L=1.8e-07 W=1.37e-06 $X=1320 $Y=2205 $D=16
.ENDS
***************************************
.SUBCKT ICV_61 1 2 3 4 5 6
*.CALIBRE ICV_CELL 9
** N=6 EP=6 IP=8 FDC=26
X1 5 1 2 4 6 3 DFKCNQD1BWP7T $T=560 0 0 0 $X=270 $Y=-235
.ENDS
***************************************
.SUBCKT FILL32BWP7T
** N=36 EP=0 IP=0 FDC=0
*.CALIBRE ISOLATED NETS: VSS VDD
.ENDS
***************************************
.SUBCKT ICV_62
** N=2 EP=0 IP=4 FDC=0
.ENDS
***************************************
.SUBCKT ICV_63
** N=2 EP=0 IP=4 FDC=0
.ENDS
***************************************
.SUBCKT ICV_64
** N=2 EP=0 IP=4 FDC=0
.ENDS
***************************************
.SUBCKT ICV_65
** N=2 EP=0 IP=4 FDC=0
.ENDS
***************************************
.SUBCKT ICV_66 1 2 3 4 5 6
*.CALIBRE ICV_CELL 9
** N=6 EP=6 IP=8 FDC=26
X1 5 1 2 4 6 3 DFKCNQD1BWP7T $T=12880 0 1 180 $X=1390 $Y=-235
.ENDS
***************************************
.SUBCKT INVD1BWP7T I VDD ZN VSS
** N=4 EP=4 IP=0 FDC=2
M0 ZN I VSS VSS N L=1.8e-07 W=1e-06 $X=840 $Y=345 $D=0
M1 ZN I VDD VDD P L=1.8e-07 W=1.37e-06 $X=840 $Y=2205 $D=16
.ENDS
***************************************
.SUBCKT ICV_67 1 2 3 4 5 6
*.CALIBRE ICV_CELL 9
** N=6 EP=6 IP=8 FDC=26
X1 5 1 2 4 6 3 DFKCNQD1BWP7T $T=13440 0 1 180 $X=1950 $Y=-235
.ENDS
***************************************
.SUBCKT ICV_68 1 2 3 4 5 6
*.CALIBRE ICV_CELL 9
** N=6 EP=6 IP=8 FDC=26
X1 5 1 2 4 6 3 DFKCNQD1BWP7T $T=11760 0 1 180 $X=270 $Y=-235
.ENDS
***************************************
.SUBCKT ICV_69 1 2 3 4 5 6
*.CALIBRE ICV_CELL 9
** N=6 EP=6 IP=8 FDC=26
X0 4 1 2 3 6 5 DFKCNQD1BWP7T $T=14000 0 1 180 $X=2510 $Y=-235
.ENDS
***************************************
.SUBCKT HA1D0BWP7T B A CO VDD S VSS
** N=13 EP=6 IP=0 FDC=18
M0 VSS 7 CO VSS N L=1.8e-07 W=5e-07 $X=645 $Y=845 $D=0
M1 12 B VSS VSS N L=1.8e-07 W=6.85e-07 $X=1265 $Y=415 $D=0
M2 7 A 12 VSS N L=1.8e-07 W=6.85e-07 $X=1820 $Y=415 $D=0
M3 VSS A 8 VSS N L=1.8e-07 W=1e-06 $X=3240 $Y=345 $D=0
M4 13 8 VSS VSS N L=1.8e-07 W=8.8e-07 $X=3960 $Y=345 $D=0
M5 10 B 13 VSS N L=1.8e-07 W=6.2e-07 $X=4635 $Y=465 $D=0
M6 8 9 10 VSS N L=1.8e-07 W=5.5e-07 $X=5460 $Y=775 $D=0
M7 VSS B 9 VSS N L=1.8e-07 W=5e-07 $X=6880 $Y=750 $D=0
M8 S 10 VSS VSS N L=1.8e-07 W=5e-07 $X=7600 $Y=750 $D=0
M9 VDD 7 CO VDD P L=1.8e-07 W=6.85e-07 $X=620 $Y=2320 $D=16
M10 7 B VDD VDD P L=1.8e-07 W=6.85e-07 $X=1225 $Y=2320 $D=16
M11 VDD A 7 VDD P L=1.8e-07 W=6.85e-07 $X=1955 $Y=2320 $D=16
M12 VDD A 8 VDD P L=1.8e-07 W=1.37e-06 $X=3240 $Y=2205 $D=16
M13 11 8 VDD VDD P L=1.8e-07 W=1.37e-06 $X=3960 $Y=2205 $D=16
M14 10 9 11 VDD P L=1.8e-07 W=1.37e-06 $X=4695 $Y=2205 $D=16
M15 8 B 10 VDD P L=1.8e-07 W=9.2e-07 $X=5420 $Y=2595 $D=16
M16 VDD B 9 VDD P L=1.8e-07 W=6.85e-07 $X=6880 $Y=2205 $D=16
M17 S 10 VDD VDD P L=1.8e-07 W=6.85e-07 $X=7600 $Y=2205 $D=16
.ENDS
***************************************
.SUBCKT INR2D1BWP7T A1 B1 VDD ZN VSS
** N=7 EP=5 IP=0 FDC=6
M0 VSS A1 6 VSS N L=1.8e-07 W=5e-07 $X=640 $Y=845 $D=0
M1 ZN 6 VSS VSS N L=1.8e-07 W=1e-06 $X=1280 $Y=345 $D=0
M2 VSS B1 ZN VSS N L=1.8e-07 W=1e-06 $X=2000 $Y=345 $D=0
M3 VDD A1 6 VDD P L=1.8e-07 W=6.85e-07 $X=620 $Y=2890 $D=16
M4 7 6 VDD VDD P L=1.8e-07 W=1.37e-06 $X=1420 $Y=2205 $D=16
M5 ZN B1 7 VDD P L=1.8e-07 W=1.37e-06 $X=2000 $Y=2205 $D=16
.ENDS
***************************************
.SUBCKT CKXOR2D1BWP7T A1 A2 VDD Z VSS
** N=11 EP=5 IP=0 FDC=12
M0 VSS A1 7 VSS N L=1.8e-07 W=9.4e-07 $X=620 $Y=405 $D=0
M1 11 6 VSS VSS N L=1.8e-07 W=4.2e-07 $X=1380 $Y=830 $D=0
M2 8 A1 11 VSS N L=1.8e-07 W=4.2e-07 $X=1980 $Y=440 $D=0
M3 6 7 8 VSS N L=1.8e-07 W=4.2e-07 $X=2740 $Y=830 $D=0
M4 VSS A2 6 VSS N L=1.8e-07 W=4.2e-07 $X=3520 $Y=440 $D=0
M5 Z 8 VSS VSS N L=1.8e-07 W=8e-07 $X=4240 $Y=440 $D=0
M6 VDD A1 7 VDD P L=1.8e-07 W=6e-07 $X=620 $Y=2205 $D=16
M7 9 6 VDD VDD P L=1.8e-07 W=9.4e-07 $X=1420 $Y=2205 $D=16
M8 8 7 9 VDD P L=1.8e-07 W=9.4e-07 $X=1960 $Y=2205 $D=16
M9 6 A1 8 VDD P L=1.8e-07 W=1.185e-06 $X=2690 $Y=2205 $D=16
M10 VDD A2 6 VDD P L=1.8e-07 W=1e-06 $X=3480 $Y=2205 $D=16
M11 Z 8 VDD VDD P L=1.8e-07 W=1.37e-06 $X=4240 $Y=2205 $D=16
.ENDS
***************************************
.SUBCKT ICV_70 1 2 3 4 5
*.CALIBRE ICV_CELL 9
** N=5 EP=5 IP=7 FDC=12
X1 3 4 2 5 1 CKXOR2D1BWP7T $T=1680 0 0 0 $X=1390 $Y=-235
.ENDS
***************************************
.SUBCKT NR2D1BWP7T A2 A1 VDD ZN VSS
** N=6 EP=5 IP=0 FDC=4
M0 ZN A2 VSS VSS N L=1.8e-07 W=1e-06 $X=660 $Y=345 $D=0
M1 VSS A1 ZN VSS N L=1.8e-07 W=1e-06 $X=1420 $Y=345 $D=0
M2 6 A2 VDD VDD P L=1.8e-07 W=1.37e-06 $X=660 $Y=2205 $D=16
M3 ZN A1 6 VDD P L=1.8e-07 W=1.37e-06 $X=1260 $Y=2205 $D=16
.ENDS
***************************************
.SUBCKT OA21D0BWP7T A2 A1 B VDD Z VSS
** N=10 EP=6 IP=0 FDC=8
M0 7 A2 10 VSS N L=1.8e-07 W=5e-07 $X=460 $Y=750 $D=0
M1 10 A1 7 VSS N L=1.8e-07 W=5e-07 $X=1180 $Y=750 $D=0
M2 VSS B 10 VSS N L=1.8e-07 W=5e-07 $X=1840 $Y=455 $D=0
M3 Z 7 VSS VSS N L=1.8e-07 W=5e-07 $X=2560 $Y=455 $D=0
M4 8 A2 VDD VDD P L=1.8e-07 W=6.85e-07 $X=460 $Y=2350 $D=16
M5 7 A1 8 VDD P L=1.8e-07 W=6.85e-07 $X=1120 $Y=2350 $D=16
M6 VDD B 7 VDD P L=1.8e-07 W=6.85e-07 $X=1840 $Y=2350 $D=16
M7 Z 7 VDD VDD P L=1.8e-07 W=6.85e-07 $X=2560 $Y=2585 $D=16
.ENDS
***************************************
.SUBCKT AN2D1BWP7T A1 A2 VDD Z VSS
** N=7 EP=5 IP=0 FDC=6
M0 7 A1 6 VSS N L=1.8e-07 W=5e-07 $X=620 $Y=345 $D=0
M1 VSS A2 7 VSS N L=1.8e-07 W=5e-07 $X=1205 $Y=345 $D=0
M2 Z 6 VSS VSS N L=1.8e-07 W=1e-06 $X=2000 $Y=345 $D=0
M3 6 A1 VDD VDD P L=1.8e-07 W=6.85e-07 $X=520 $Y=2205 $D=16
M4 VDD A2 6 VDD P L=1.8e-07 W=6.85e-07 $X=1240 $Y=2205 $D=16
M5 Z 6 VDD VDD P L=1.8e-07 W=1.37e-06 $X=2000 $Y=2205 $D=16
.ENDS
***************************************
.SUBCKT ND2D1BWP7T A2 A1 VDD ZN VSS
** N=6 EP=5 IP=0 FDC=4
M0 6 A2 VSS VSS N L=1.8e-07 W=1e-06 $X=660 $Y=345 $D=0
M1 ZN A1 6 VSS N L=1.8e-07 W=1e-06 $X=1300 $Y=345 $D=0
M2 ZN A2 VDD VDD P L=1.8e-07 W=1.37e-06 $X=660 $Y=2205 $D=16
M3 VDD A1 ZN VDD P L=1.8e-07 W=1.37e-06 $X=1380 $Y=2205 $D=16
.ENDS
***************************************
.SUBCKT TIELBWP7T VDD VSS ZN
** N=4 EP=3 IP=0 FDC=2
M0 ZN 4 VSS VSS N L=1.8e-07 W=1e-06 $X=760 $Y=345 $D=0
M1 VDD 4 4 VDD P L=1.8e-07 W=1.37e-06 $X=760 $Y=2205 $D=16
.ENDS
***************************************
.SUBCKT ICV_71
** N=2 EP=0 IP=4 FDC=0
.ENDS
***************************************
.SUBCKT ICV_72
** N=2 EP=0 IP=4 FDC=0
.ENDS
***************************************
.SUBCKT CKBD1BWP7T I VDD Z VSS
** N=6 EP=4 IP=0 FDC=4
M0 VSS I 5 VSS N L=1.8e-07 W=4.55e-07 $X=620 $Y=425 $D=0
M1 Z 5 VSS VSS N L=1.8e-07 W=5.2e-07 $X=1440 $Y=360 $D=0
M2 VDD I 5 VDD P L=1.8e-07 W=1.37e-06 $X=620 $Y=2205 $D=16
M3 Z 5 VDD VDD P L=1.8e-07 W=1.37e-06 $X=1440 $Y=2205 $D=16
.ENDS
***************************************
.SUBCKT ICV_73 1 2 3 4 5
*.CALIBRE ICV_CELL 9
** N=5 EP=5 IP=7 FDC=6
X1 3 5 2 4 1 INR2D1BWP7T $T=1120 0 0 0 $X=830 $Y=-235
.ENDS
***************************************
.SUBCKT ICV_74 1 2 3 4 5
*.CALIBRE ICV_CELL 9
** N=5 EP=5 IP=7 FDC=6
X1 3 5 2 4 1 INR2D1BWP7T $T=1680 0 0 0 $X=1390 $Y=-235
.ENDS
***************************************
.SUBCKT ICV_75 1 2 3 4 5 6
*.CALIBRE ICV_CELL 9
** N=6 EP=6 IP=8 FDC=26
X1 5 1 2 4 6 3 DFKCNQD1BWP7T $T=14560 0 1 180 $X=3070 $Y=-235
.ENDS
***************************************
.SUBCKT ICV_76 1 2 3 4 5
*.CALIBRE ICV_CELL 9
** N=5 EP=5 IP=7 FDC=4
X1 3 5 2 4 1 ND2D1BWP7T $T=3920 0 1 180 $X=1390 $Y=-235
.ENDS
***************************************
.SUBCKT ICV_77 1 2 3 4 5
*.CALIBRE ICV_CELL 9
** N=5 EP=5 IP=7 FDC=6
X1 3 5 2 4 1 INR2XD0BWP7T $T=4480 0 1 180 $X=1390 $Y=-235
.ENDS
***************************************
.SUBCKT CKLNQD1BWP7T TE E CP VDD Q VSS
** N=18 EP=6 IP=0 FDC=22
M0 VSS TE 15 VSS N L=1.8e-07 W=5e-07 $X=620 $Y=480 $D=0
M1 15 E VSS VSS N L=1.8e-07 W=5e-07 $X=1340 $Y=480 $D=0
M2 9 10 15 VSS N L=1.8e-07 W=5e-07 $X=2060 $Y=480 $D=0
M3 17 7 9 VSS N L=1.8e-07 W=4.2e-07 $X=2820 $Y=480 $D=0
M4 VSS 8 17 VSS N L=1.8e-07 W=4.2e-07 $X=3310 $Y=480 $D=0
M5 8 9 VSS VSS N L=1.8e-07 W=5e-07 $X=4040 $Y=480 $D=0
M6 VSS 10 7 VSS N L=1.8e-07 W=5e-07 $X=5475 $Y=1000 $D=0
M7 10 CP VSS VSS N L=1.8e-07 W=5e-07 $X=6095 $Y=845 $D=0
M8 18 CP 11 VSS N L=1.8e-07 W=5e-07 $X=7570 $Y=785 $D=0
M9 VSS 8 18 VSS N L=1.8e-07 W=5e-07 $X=8000 $Y=785 $D=0
M10 Q 11 VSS VSS N L=1.8e-07 W=5.25e-07 $X=8720 $Y=760 $D=0
M11 12 TE VDD VDD P L=1.8e-07 W=1.37e-06 $X=620 $Y=2205 $D=16
M12 13 E 12 VDD P L=1.8e-07 W=1.37e-06 $X=1220 $Y=2205 $D=16
M13 9 7 13 VDD P L=1.8e-07 W=5.2e-07 $X=1820 $Y=2380 $D=16
M14 14 10 9 VDD P L=1.8e-07 W=4.2e-07 $X=2540 $Y=2380 $D=16
M15 VDD 8 14 VDD P L=1.8e-07 W=4.2e-07 $X=2990 $Y=2380 $D=16
M16 8 9 VDD VDD P L=1.8e-07 W=6.85e-07 $X=3840 $Y=2380 $D=16
M17 VDD 10 7 VDD P L=1.8e-07 W=6.85e-07 $X=5260 $Y=2660 $D=16
M18 10 CP VDD VDD P L=1.8e-07 W=6.85e-07 $X=5980 $Y=2660 $D=16
M19 11 CP VDD VDD P L=1.8e-07 W=9e-07 $X=7280 $Y=2675 $D=16
M20 VDD 8 11 VDD P L=1.8e-07 W=8.5e-07 $X=8000 $Y=2725 $D=16
M21 Q 11 VDD VDD P L=1.8e-07 W=1.37e-06 $X=8720 $Y=2205 $D=16
.ENDS
***************************************
.SUBCKT ICV_78
** N=2 EP=0 IP=4 FDC=0
.ENDS
***************************************
.SUBCKT ICV_79
** N=2 EP=0 IP=4 FDC=0
.ENDS
***************************************
.SUBCKT ICV_80
** N=2 EP=0 IP=4 FDC=0
.ENDS
***************************************
.SUBCKT ICV_81
** N=2 EP=0 IP=4 FDC=0
.ENDS
***************************************
.SUBCKT ICV_82
** N=2 EP=0 IP=4 FDC=0
.ENDS
***************************************
.SUBCKT ICV_83
** N=2 EP=0 IP=4 FDC=0
.ENDS
***************************************
.SUBCKT ICV_84
** N=2 EP=0 IP=4 FDC=0
.ENDS
***************************************
.SUBCKT ICV_85
** N=2 EP=0 IP=4 FDC=0
.ENDS
***************************************
.SUBCKT ICV_86 1 2 3 4 5 6
*.CALIBRE ICV_CELL 9
** N=6 EP=6 IP=8 FDC=26
X1 5 1 2 4 6 3 DFKCNQD1BWP7T $T=1120 0 0 0 $X=830 $Y=-235
.ENDS
***************************************
.SUBCKT ICV_87
** N=2 EP=0 IP=4 FDC=0
.ENDS
***************************************
.SUBCKT ICV_88
** N=2 EP=0 IP=4 FDC=0
.ENDS
***************************************
.SUBCKT ICV_89
** N=2 EP=0 IP=4 FDC=0
.ENDS
***************************************
.SUBCKT ICV_90
** N=2 EP=0 IP=4 FDC=0
.ENDS
***************************************
.SUBCKT ICV_91
** N=2 EP=0 IP=4 FDC=0
.ENDS
***************************************
.SUBCKT ICV_92
** N=2 EP=0 IP=4 FDC=0
.ENDS
***************************************
.SUBCKT ICV_93
** N=2 EP=0 IP=4 FDC=0
.ENDS
***************************************
.SUBCKT ICV_94
** N=2 EP=0 IP=4 FDC=0
.ENDS
***************************************
.SUBCKT ICV_95
** N=2 EP=0 IP=4 FDC=0
.ENDS
***************************************
.SUBCKT ICV_96
** N=2 EP=0 IP=4 FDC=0
.ENDS
***************************************
.SUBCKT ICV_97
** N=2 EP=0 IP=4 FDC=0
.ENDS
***************************************
.SUBCKT ICV_98 1 2 3 4 5
*.CALIBRE ICV_CELL 9
** N=5 EP=5 IP=7 FDC=6
X1 3 5 2 4 1 INR2D1BWP7T $T=0 0 0 0 $X=-290 $Y=-235
.ENDS
***************************************
.SUBCKT CKMUX2D1BWP7T S I0 I1 VDD Z VSS
** N=13 EP=6 IP=0 FDC=12
M0 VSS S 7 VSS N L=1.8e-07 W=5.25e-07 $X=620 $Y=345 $D=0
M1 12 I0 VSS VSS N L=1.8e-07 W=4.65e-07 $X=1420 $Y=345 $D=0
M2 8 7 12 VSS N L=1.8e-07 W=4.65e-07 $X=2090 $Y=345 $D=0
M3 13 S 8 VSS N L=1.8e-07 W=4.65e-07 $X=2820 $Y=345 $D=0
M4 VSS I1 13 VSS N L=1.8e-07 W=4.65e-07 $X=3440 $Y=345 $D=0
M5 Z 8 VSS VSS N L=1.8e-07 W=7e-07 $X=4240 $Y=345 $D=0
M6 VDD S 7 VDD P L=1.8e-07 W=1.37e-06 $X=620 $Y=2205 $D=16
M7 9 I0 VDD VDD P L=1.8e-07 W=1.37e-06 $X=1430 $Y=2205 $D=16
M8 8 S 9 VDD P L=1.8e-07 W=1.37e-06 $X=2100 $Y=2205 $D=16
M9 10 7 8 VDD P L=1.8e-07 W=1.37e-06 $X=3070 $Y=2205 $D=16
M10 VDD I1 10 VDD P L=1.8e-07 W=1.37e-06 $X=3520 $Y=2205 $D=16
M11 Z 8 VDD VDD P L=1.8e-07 W=1.37e-06 $X=4240 $Y=2205 $D=16
.ENDS
***************************************
.SUBCKT ICV_99 1 2 3 4 5
*.CALIBRE ICV_CELL 9
** N=5 EP=5 IP=7 FDC=6
X1 3 5 2 4 1 INR2XD0BWP7T $T=0 0 0 0 $X=-290 $Y=-235
.ENDS
***************************************
.SUBCKT IND3D1BWP7T A1 B1 B2 VDD ZN VSS
** N=9 EP=6 IP=0 FDC=8
M0 VSS A1 7 VSS N L=1.8e-07 W=5e-07 $X=620 $Y=360 $D=0
M1 8 7 VSS VSS N L=1.8e-07 W=1e-06 $X=1420 $Y=345 $D=0
M2 9 B1 8 VSS N L=1.8e-07 W=1e-06 $X=1980 $Y=345 $D=0
M3 ZN B2 9 VSS N L=1.8e-07 W=1e-06 $X=2540 $Y=345 $D=0
M4 VDD A1 7 VDD P L=1.8e-07 W=6.85e-07 $X=620 $Y=2205 $D=16
M5 ZN 7 VDD VDD P L=1.8e-07 W=1.37e-06 $X=1225 $Y=2205 $D=16
M6 VDD B1 ZN VDD P L=1.8e-07 W=8.35e-07 $X=1945 $Y=2205 $D=16
M7 ZN B2 VDD VDD P L=1.8e-07 W=1.37e-06 $X=2560 $Y=2205 $D=16
.ENDS
***************************************
.SUBCKT ICV_100
** N=2 EP=0 IP=4 FDC=0
.ENDS
***************************************
.SUBCKT ICV_101
** N=2 EP=0 IP=4 FDC=0
.ENDS
***************************************
.SUBCKT OR2D1BWP7T A1 A2 VDD Z VSS
** N=7 EP=5 IP=0 FDC=6
M0 6 A1 VSS VSS N L=1.8e-07 W=5e-07 $X=660 $Y=845 $D=0
M1 VSS A2 6 VSS N L=1.8e-07 W=5e-07 $X=1380 $Y=845 $D=0
M2 Z 6 VSS VSS N L=1.8e-07 W=1e-06 $X=2000 $Y=345 $D=0
M3 7 A1 6 VDD P L=1.8e-07 W=1.37e-06 $X=660 $Y=2205 $D=16
M4 VDD A2 7 VDD P L=1.8e-07 W=1.37e-06 $X=1200 $Y=2205 $D=16
M5 Z 6 VDD VDD P L=1.8e-07 W=1.37e-06 $X=2000 $Y=2205 $D=16
.ENDS
***************************************
.SUBCKT CKAN2D1BWP7T A1 A2 VDD Z VSS
** N=10 EP=5 IP=0 FDC=6
M0 10 A1 6 VSS N L=1.8e-07 W=5e-07 $X=620 $Y=515 $D=0
M1 VSS A2 10 VSS N L=1.8e-07 W=5e-07 $X=1090 $Y=515 $D=0
M2 Z 6 VSS VSS N L=1.8e-07 W=5.25e-07 $X=2000 $Y=515 $D=0
M3 6 A1 VDD VDD P L=1.8e-07 W=8.5e-07 $X=520 $Y=2205 $D=16
M4 VDD A2 6 VDD P L=1.8e-07 W=9e-07 $X=1240 $Y=2205 $D=16
M5 Z 6 VDD VDD P L=1.8e-07 W=1.37e-06 $X=2000 $Y=2205 $D=16
.ENDS
***************************************
.SUBCKT ICV_102 1 2 3 4 5 6
*.CALIBRE ICV_CELL 9
** N=6 EP=6 IP=8 FDC=18
X1 5 4 3 2 6 1 HA1D0BWP7T $T=1680 0 0 0 $X=1390 $Y=-235
.ENDS
***************************************
.SUBCKT INVD0BWP7T I VDD ZN VSS
** N=4 EP=4 IP=0 FDC=2
M0 ZN I VSS VSS N L=1.8e-07 W=5e-07 $X=840 $Y=560 $D=0
M1 ZN I VDD VDD P L=1.8e-07 W=6.85e-07 $X=840 $Y=2575 $D=16
.ENDS
***************************************
.SUBCKT CKBD2BWP7T I VDD Z VSS
** N=5 EP=4 IP=0 FDC=6
M0 VSS I 5 VSS N L=1.8e-07 W=5.25e-07 $X=1120 $Y=460 $D=0
M1 Z 5 VSS VSS N L=1.8e-07 W=5.25e-07 $X=1840 $Y=460 $D=0
M2 VSS 5 Z VSS N L=1.8e-07 W=5.25e-07 $X=2560 $Y=460 $D=0
M3 VDD I 5 VDD P L=1.8e-07 W=1.54e-06 $X=1120 $Y=2035 $D=16
M4 Z 5 VDD VDD P L=1.8e-07 W=1.37e-06 $X=1840 $Y=2205 $D=16
M5 VDD 5 Z VDD P L=1.8e-07 W=1.37e-06 $X=2560 $Y=2205 $D=16
.ENDS
***************************************
.SUBCKT ICV_103 1 2 3 4 5 6
*.CALIBRE ICV_CELL 9
** N=6 EP=6 IP=8 FDC=26
X1 5 1 2 4 6 3 DFKCNQD1BWP7T $T=12320 0 1 180 $X=830 $Y=-235
.ENDS
***************************************
.SUBCKT ICV_104 1 2 3 4 5 6
*.CALIBRE ICV_CELL 9
** N=6 EP=6 IP=8 FDC=26
X1 5 1 2 4 6 3 DFKCNQD1BWP7T $T=0 0 0 0 $X=-290 $Y=-235
.ENDS
***************************************
.SUBCKT ICV_105 1 2 3 4 5 6
*.CALIBRE ICV_CELL 9
** N=6 EP=6 IP=8 FDC=26
X1 5 1 2 4 6 3 DFKCNQD1BWP7T $T=0 0 0 0 $X=-290 $Y=-235
.ENDS
***************************************
.SUBCKT ICV_106 1 2 3 4 5 6
*.CALIBRE ICV_CELL 9
** N=6 EP=6 IP=8 FDC=26
X1 5 1 2 4 6 3 DFKCNQD1BWP7T $T=0 0 0 0 $X=-290 $Y=-235
.ENDS
***************************************
.SUBCKT IND2D1BWP7T A1 B1 VDD ZN VSS
** N=7 EP=5 IP=0 FDC=6
M0 VSS A1 6 VSS N L=1.8e-07 W=5e-07 $X=620 $Y=565 $D=0
M1 7 6 VSS VSS N L=1.8e-07 W=1e-06 $X=1420 $Y=345 $D=0
M2 ZN B1 7 VSS N L=1.8e-07 W=1e-06 $X=2000 $Y=345 $D=0
M3 VDD A1 6 VDD P L=1.8e-07 W=6.85e-07 $X=620 $Y=2205 $D=16
M4 ZN 6 VDD VDD P L=1.8e-07 W=1.37e-06 $X=1280 $Y=2205 $D=16
M5 VDD B1 ZN VDD P L=1.8e-07 W=1.37e-06 $X=2000 $Y=2205 $D=16
.ENDS
***************************************
.SUBCKT XNR2D1BWP7T A1 A2 VDD ZN VSS
** N=11 EP=5 IP=0 FDC=12
M0 VSS A1 7 VSS N L=1.8e-07 W=5e-07 $X=625 $Y=460 $D=0
M1 11 6 VSS VSS N L=1.8e-07 W=5e-07 $X=1425 $Y=845 $D=0
M2 8 7 11 VSS N L=1.8e-07 W=5e-07 $X=1855 $Y=845 $D=0
M3 6 A1 8 VSS N L=1.8e-07 W=5e-07 $X=2725 $Y=440 $D=0
M4 VSS A2 6 VSS N L=1.8e-07 W=1e-06 $X=3485 $Y=345 $D=0
M5 ZN 8 VSS VSS N L=1.8e-07 W=1e-06 $X=4235 $Y=345 $D=0
M6 VDD A1 7 VDD P L=1.8e-07 W=6.85e-07 $X=625 $Y=2530 $D=16
M7 9 6 VDD VDD P L=1.8e-07 W=6.85e-07 $X=1425 $Y=2445 $D=16
M8 8 A1 9 VDD P L=1.8e-07 W=6.85e-07 $X=1935 $Y=2445 $D=16
M9 6 7 8 VDD P L=1.8e-07 W=6.85e-07 $X=2685 $Y=2445 $D=16
M10 VDD A2 6 VDD P L=1.8e-07 W=1.37e-06 $X=3465 $Y=2205 $D=16
M11 ZN 8 VDD VDD P L=1.8e-07 W=1.37e-06 $X=4235 $Y=2205 $D=16
.ENDS
***************************************
.SUBCKT EDFKCNQD1BWP7T D E CN CP VDD Q VSS
** N=25 EP=7 IP=0 FDC=34
M0 8 E VSS VSS N L=1.8e-07 W=5e-07 $X=620 $Y=560 $D=0
M1 22 E 24 VSS N L=1.8e-07 W=5.7e-07 $X=1880 $Y=680 $D=0
M2 17 D 22 VSS N L=1.8e-07 W=5.7e-07 $X=2310 $Y=680 $D=0
M3 23 8 17 VSS N L=1.8e-07 W=4.2e-07 $X=3030 $Y=680 $D=0
M4 24 9 23 VSS N L=1.8e-07 W=4.2e-07 $X=3515 $Y=680 $D=0
M5 VSS CN 24 VSS N L=1.8e-07 W=1e-06 $X=4115 $Y=345 $D=0
M6 VSS CP 13 VSS N L=1.8e-07 W=5e-07 $X=5615 $Y=980 $D=0
M7 10 13 VSS VSS N L=1.8e-07 W=5e-07 $X=6275 $Y=805 $D=0
M8 12 13 17 VSS N L=1.8e-07 W=9.1e-07 $X=7800 $Y=405 $D=0
M9 25 10 12 VSS N L=1.8e-07 W=4.2e-07 $X=8520 $Y=895 $D=0
M10 VSS 11 25 VSS N L=1.8e-07 W=4.2e-07 $X=8950 $Y=895 $D=0
M11 11 12 VSS VSS N L=1.8e-07 W=9.7e-07 $X=9620 $Y=345 $D=0
M12 15 10 11 VSS N L=1.8e-07 W=6.35e-07 $X=10450 $Y=615 $D=0
M13 9 13 15 VSS N L=1.8e-07 W=4.2e-07 $X=11340 $Y=830 $D=0
M14 VSS 14 9 VSS N L=1.8e-07 W=4.2e-07 $X=12100 $Y=710 $D=0
M15 14 15 VSS VSS N L=1.8e-07 W=6.65e-07 $X=13000 $Y=680 $D=0
M16 Q 14 VSS VSS N L=1.8e-07 W=1e-06 $X=14320 $Y=345 $D=0
M17 VDD E 8 VDD P L=1.8e-07 W=6.85e-07 $X=620 $Y=2685 $D=16
M18 16 8 VDD VDD P L=1.8e-07 W=7.2e-07 $X=1495 $Y=2425 $D=16
M19 17 D 16 VDD P L=1.8e-07 W=7.2e-07 $X=2070 $Y=2425 $D=16
M20 18 E 17 VDD P L=1.8e-07 W=4.2e-07 $X=2970 $Y=2865 $D=16
M21 VDD 9 18 VDD P L=1.8e-07 W=4.2e-07 $X=3515 $Y=2865 $D=16
M22 17 CN VDD VDD P L=1.8e-07 W=4.2e-07 $X=4355 $Y=3130 $D=16
M23 VDD CP 13 VDD P L=1.8e-07 W=6.85e-07 $X=5615 $Y=2345 $D=16
M24 10 13 VDD VDD P L=1.8e-07 W=6.85e-07 $X=6410 $Y=2345 $D=16
M25 12 10 17 VDD P L=1.8e-07 W=6.5e-07 $X=7830 $Y=2175 $D=16
M26 19 13 12 VDD P L=1.8e-07 W=4.2e-07 $X=8550 $Y=2405 $D=16
M27 VDD 11 19 VDD P L=1.8e-07 W=4.2e-07 $X=8980 $Y=2405 $D=16
M28 11 12 VDD VDD P L=1.8e-07 W=9.7e-07 $X=9780 $Y=2175 $D=16
M29 15 13 11 VDD P L=1.8e-07 W=1.215e-06 $X=10720 $Y=2300 $D=16
M30 9 10 15 VDD P L=1.8e-07 W=4.2e-07 $X=11560 $Y=2610 $D=16
M31 VDD 14 9 VDD P L=1.8e-07 W=4.2e-07 $X=12280 $Y=2610 $D=16
M32 14 15 VDD VDD P L=1.8e-07 W=1.37e-06 $X=13000 $Y=2205 $D=16
M33 Q 14 VDD VDD P L=1.8e-07 W=1.37e-06 $X=14320 $Y=2205 $D=16
.ENDS
***************************************
.SUBCKT CKND1BWP7T I VDD ZN VSS
** N=4 EP=4 IP=0 FDC=2
M0 ZN I VSS VSS N L=1.8e-07 W=5.25e-07 $X=830 $Y=440 $D=0
M1 ZN I VDD VDD P L=1.8e-07 W=1.37e-06 $X=830 $Y=2205 $D=16
.ENDS
***************************************
.SUBCKT ICV_107
** N=2 EP=0 IP=4 FDC=0
.ENDS
***************************************
.SUBCKT ICV_108
** N=2 EP=0 IP=4 FDC=0
.ENDS
***************************************
.SUBCKT ICV_109 1 2 3 4 5
*.CALIBRE ICV_CELL 9
** N=5 EP=5 IP=7 FDC=6
X1 3 5 2 4 1 INR2D1BWP7T $T=4480 0 1 180 $X=1390 $Y=-235
.ENDS
***************************************
.SUBCKT AO21D0BWP7T A2 A1 B VDD Z VSS
** N=10 EP=6 IP=0 FDC=8
M0 10 A2 VSS VSS N L=1.8e-07 W=5e-07 $X=620 $Y=460 $D=0
M1 7 A1 10 VSS N L=1.8e-07 W=5e-07 $X=1120 $Y=460 $D=0
M2 VSS B 7 VSS N L=1.8e-07 W=5e-07 $X=1840 $Y=460 $D=0
M3 Z 7 VSS VSS N L=1.8e-07 W=5e-07 $X=2560 $Y=460 $D=0
M4 7 A2 8 VDD P L=1.8e-07 W=6.85e-07 $X=490 $Y=2555 $D=16
M5 8 A1 7 VDD P L=1.8e-07 W=6.85e-07 $X=1210 $Y=2555 $D=16
M6 VDD B 8 VDD P L=1.8e-07 W=6.85e-07 $X=1840 $Y=2555 $D=16
M7 Z 7 VDD VDD P L=1.8e-07 W=6.85e-07 $X=2560 $Y=2555 $D=16
.ENDS
***************************************
.SUBCKT NR4D0BWP7T A4 A3 A2 A1 VDD ZN VSS
** N=11 EP=7 IP=0 FDC=8
M0 ZN A4 VSS VSS N L=1.8e-07 W=5e-07 $X=625 $Y=725 $D=0
M1 VSS A3 ZN VSS N L=1.8e-07 W=5e-07 $X=1345 $Y=725 $D=0
M2 ZN A2 VSS VSS N L=1.8e-07 W=5e-07 $X=1945 $Y=725 $D=0
M3 VSS A1 ZN VSS N L=1.8e-07 W=5e-07 $X=2680 $Y=725 $D=0
M4 8 A4 VDD VDD P L=1.8e-07 W=1.37e-06 $X=625 $Y=2205 $D=16
M5 9 A3 8 VDD P L=1.8e-07 W=1.37e-06 $X=1265 $Y=2205 $D=16
M6 10 A2 9 VDD P L=1.8e-07 W=1.37e-06 $X=1905 $Y=2205 $D=16
M7 ZN A1 10 VDD P L=1.8e-07 W=1.37e-06 $X=2545 $Y=2205 $D=16
.ENDS
***************************************
.SUBCKT INR3D0BWP7T A1 B1 B2 VDD ZN VSS
** N=9 EP=6 IP=0 FDC=8
M0 VSS A1 7 VSS N L=1.8e-07 W=4.2e-07 $X=620 $Y=500 $D=0
M1 ZN 7 VSS VSS N L=1.8e-07 W=5e-07 $X=1340 $Y=500 $D=0
M2 VSS B1 ZN VSS N L=1.8e-07 W=5e-07 $X=2160 $Y=500 $D=0
M3 ZN B2 VSS VSS N L=1.8e-07 W=5e-07 $X=3120 $Y=500 $D=0
M4 VDD A1 7 VDD P L=1.8e-07 W=4.2e-07 $X=620 $Y=2470 $D=16
M5 8 7 VDD VDD P L=1.8e-07 W=1.37e-06 $X=1440 $Y=2205 $D=16
M6 9 B1 8 VDD P L=1.8e-07 W=1.37e-06 $X=2280 $Y=2205 $D=16
M7 ZN B2 9 VDD P L=1.8e-07 W=1.37e-06 $X=3120 $Y=2205 $D=16
.ENDS
***************************************
.SUBCKT AOI222D0BWP7T C2 C1 B1 B2 A2 A1 VDD ZN VSS
** N=14 EP=9 IP=0 FDC=12
M0 12 C2 VSS VSS N L=1.8e-07 W=5e-07 $X=625 $Y=475 $D=0
M1 ZN C1 12 VSS N L=1.8e-07 W=5e-07 $X=1220 $Y=475 $D=0
M2 13 B1 ZN VSS N L=1.8e-07 W=5e-07 $X=1940 $Y=475 $D=0
M3 VSS B2 13 VSS N L=1.8e-07 W=5e-07 $X=2440 $Y=475 $D=0
M4 14 A2 VSS VSS N L=1.8e-07 W=5e-07 $X=3240 $Y=475 $D=0
M5 ZN A1 14 VSS N L=1.8e-07 W=5e-07 $X=3740 $Y=475 $D=0
M6 VDD C2 10 VDD P L=1.8e-07 W=6.85e-07 $X=625 $Y=2315 $D=16
M7 10 C1 VDD VDD P L=1.8e-07 W=6.85e-07 $X=1380 $Y=2315 $D=16
M8 11 B1 10 VDD P L=1.8e-07 W=6.85e-07 $X=2180 $Y=2315 $D=16
M9 ZN A2 11 VDD P L=1.8e-07 W=6.85e-07 $X=2860 $Y=2315 $D=16
M10 11 A1 ZN VDD P L=1.8e-07 W=6.85e-07 $X=3580 $Y=2315 $D=16
M11 10 B2 11 VDD P L=1.8e-07 W=6.85e-07 $X=4240 $Y=2315 $D=16
.ENDS
***************************************
.SUBCKT AOI22D0BWP7T B2 B1 A1 A2 VDD ZN VSS
** N=11 EP=7 IP=0 FDC=8
M0 10 B2 VSS VSS N L=1.8e-07 W=5e-07 $X=620 $Y=345 $D=0
M1 ZN B1 10 VSS N L=1.8e-07 W=5e-07 $X=1165 $Y=345 $D=0
M2 11 A1 ZN VSS N L=1.8e-07 W=5e-07 $X=1940 $Y=345 $D=0
M3 VSS A2 11 VSS N L=1.8e-07 W=5e-07 $X=2560 $Y=345 $D=0
M4 8 B2 VDD VDD P L=1.8e-07 W=6.85e-07 $X=620 $Y=2755 $D=16
M5 ZN A1 8 VDD P L=1.8e-07 W=6.85e-07 $X=1225 $Y=2555 $D=16
M6 8 A2 ZN VDD P L=1.8e-07 W=6.85e-07 $X=1945 $Y=2555 $D=16
M7 VDD B1 8 VDD P L=1.8e-07 W=6.85e-07 $X=2560 $Y=2890 $D=16
.ENDS
***************************************
.SUBCKT NR2D2BWP7T A2 A1 VDD ZN VSS
** N=6 EP=5 IP=0 FDC=8
M0 ZN A2 VSS VSS N L=1.8e-07 W=1e-06 $X=660 $Y=345 $D=0
M1 VSS A2 ZN VSS N L=1.8e-07 W=1e-06 $X=1380 $Y=345 $D=0
M2 ZN A1 VSS VSS N L=1.8e-07 W=1e-06 $X=2240 $Y=345 $D=0
M3 VSS A1 ZN VSS N L=1.8e-07 W=1e-06 $X=2960 $Y=345 $D=0
M4 VDD A2 6 VDD P L=1.8e-07 W=1.37e-06 $X=660 $Y=2205 $D=16
M5 6 A2 VDD VDD P L=1.8e-07 W=1.37e-06 $X=1380 $Y=2205 $D=16
M6 ZN A1 6 VDD P L=1.8e-07 W=1.37e-06 $X=2240 $Y=2205 $D=16
M7 6 A1 ZN VDD P L=1.8e-07 W=1.37e-06 $X=2960 $Y=2205 $D=16
.ENDS
***************************************
.SUBCKT AO31D1BWP7T A3 A2 A1 B VDD Z VSS
** N=11 EP=7 IP=0 FDC=10
M0 10 A3 VSS VSS N L=1.8e-07 W=1e-06 $X=680 $Y=345 $D=0
M1 11 A2 10 VSS N L=1.8e-07 W=1e-06 $X=1300 $Y=345 $D=0
M2 8 A1 11 VSS N L=1.8e-07 W=1e-06 $X=1920 $Y=345 $D=0
M3 VSS B 8 VSS N L=1.8e-07 W=1e-06 $X=2755 $Y=345 $D=0
M4 Z 8 VSS VSS N L=1.8e-07 W=1e-06 $X=3665 $Y=345 $D=0
M5 9 A3 8 VDD P L=1.8e-07 W=1.37e-06 $X=680 $Y=2205 $D=16
M6 8 A2 9 VDD P L=1.8e-07 W=1.37e-06 $X=1400 $Y=2205 $D=16
M7 9 A1 8 VDD P L=1.8e-07 W=1.37e-06 $X=2160 $Y=2205 $D=16
M8 VDD B 9 VDD P L=1.8e-07 W=1.37e-06 $X=2905 $Y=2205 $D=16
M9 Z 8 VDD VDD P L=1.8e-07 W=1.37e-06 $X=3665 $Y=2205 $D=16
.ENDS
***************************************
.SUBCKT IOA21D1BWP7T A1 A2 B VDD ZN VSS
** N=9 EP=6 IP=0 FDC=8
M0 8 A1 7 VSS N L=1.8e-07 W=5e-07 $X=625 $Y=345 $D=0
M1 VSS A2 8 VSS N L=1.8e-07 W=5e-07 $X=1205 $Y=345 $D=0
M2 9 7 VSS VSS N L=1.8e-07 W=1e-06 $X=1975 $Y=345 $D=0
M3 ZN B 9 VSS N L=1.8e-07 W=1e-06 $X=2560 $Y=345 $D=0
M4 7 A1 VDD VDD P L=1.8e-07 W=6.85e-07 $X=465 $Y=2205 $D=16
M5 VDD A2 7 VDD P L=1.8e-07 W=6.85e-07 $X=1185 $Y=2205 $D=16
M6 ZN 7 VDD VDD P L=1.8e-07 W=1.37e-06 $X=1840 $Y=2205 $D=16
M7 VDD B ZN VDD P L=1.8e-07 W=1.37e-06 $X=2560 $Y=2205 $D=16
.ENDS
***************************************
.SUBCKT CKBD3BWP7T I VDD Z VSS
** N=5 EP=4 IP=0 FDC=9
M0 5 I VSS VSS N L=1.8e-07 W=8e-07 $X=1385 $Y=440 $D=0
M1 Z 5 VSS VSS N L=1.8e-07 W=8.3e-07 $X=2905 $Y=440 $D=0
M2 VSS 5 Z VSS N L=1.8e-07 W=8.3e-07 $X=3625 $Y=440 $D=0
M3 5 I VDD VDD P L=1.8e-07 W=1.14e-06 $X=660 $Y=2435 $D=16
M4 VDD I 5 VDD P L=1.8e-07 W=1.14e-06 $X=1385 $Y=2435 $D=16
M5 Z 5 VDD VDD P L=1.8e-07 W=1.37e-06 $X=2105 $Y=2205 $D=16
M6 VDD 5 Z VDD P L=1.8e-07 W=1.37e-06 $X=2825 $Y=2205 $D=16
M7 Z 5 VDD VDD P L=1.8e-07 W=1.37e-06 $X=3625 $Y=2205 $D=16
D8 VSS I DN AREA=2.037e-13 PJ=1.81e-06 $X=140 $Y=855 $D=26
.ENDS
***************************************
.SUBCKT ICV_110 1 2 3 4 5 6
*.CALIBRE ICV_CELL 9
** N=6 EP=6 IP=8 FDC=26
X1 5 1 2 4 6 3 DFKCNQD1BWP7T $T=0 0 0 0 $X=-290 $Y=-235
.ENDS
***************************************
.SUBCKT AOI221D0BWP7T C B1 B2 A2 A1 VDD ZN VSS
** N=12 EP=8 IP=0 FDC=10
M0 ZN C VSS VSS N L=1.8e-07 W=5e-07 $X=640 $Y=500 $D=0
M1 11 B1 ZN VSS N L=1.8e-07 W=5e-07 $X=1385 $Y=500 $D=0
M2 VSS B2 11 VSS N L=1.8e-07 W=5e-07 $X=1825 $Y=500 $D=0
M3 12 A2 VSS VSS N L=1.8e-07 W=5e-07 $X=2625 $Y=500 $D=0
M4 ZN A1 12 VSS N L=1.8e-07 W=5e-07 $X=3215 $Y=500 $D=0
M5 9 C VDD VDD P L=1.8e-07 W=6.85e-07 $X=640 $Y=2785 $D=16
M6 10 B1 9 VDD P L=1.8e-07 W=6.85e-07 $X=1360 $Y=2785 $D=16
M7 ZN A2 10 VDD P L=1.8e-07 W=6.85e-07 $X=2085 $Y=2415 $D=16
M8 10 A1 ZN VDD P L=1.8e-07 W=6.85e-07 $X=2975 $Y=2415 $D=16
M9 9 B2 10 VDD P L=1.8e-07 W=6.85e-07 $X=3680 $Y=2415 $D=16
.ENDS
***************************************
.SUBCKT AOI21D0BWP7T A2 A1 B ZN VDD VSS
** N=8 EP=6 IP=0 FDC=6
M0 8 A2 VSS VSS N L=1.8e-07 W=5e-07 $X=630 $Y=460 $D=0
M1 ZN A1 8 VSS N L=1.8e-07 W=5e-07 $X=1250 $Y=460 $D=0
M2 VSS B ZN VSS N L=1.8e-07 W=5e-07 $X=1975 $Y=460 $D=0
M3 ZN A2 7 VDD P L=1.8e-07 W=6.85e-07 $X=630 $Y=2275 $D=16
M4 7 A1 ZN VDD P L=1.8e-07 W=6.85e-07 $X=1355 $Y=2275 $D=16
M5 VDD B 7 VDD P L=1.8e-07 W=6.85e-07 $X=2075 $Y=2275 $D=16
.ENDS
***************************************
.SUBCKT ICV_111
** N=2 EP=0 IP=4 FDC=0
.ENDS
***************************************
.SUBCKT ICV_112
** N=2 EP=0 IP=4 FDC=0
.ENDS
***************************************
.SUBCKT ICV_113
** N=2 EP=0 IP=4 FDC=0
.ENDS
***************************************
.SUBCKT ICV_114
** N=2 EP=0 IP=4 FDC=0
.ENDS
***************************************
.SUBCKT CKND2D1BWP7T A2 A1 VDD ZN VSS
** N=6 EP=5 IP=0 FDC=4
M0 6 A2 VSS VSS N L=1.8e-07 W=6.85e-07 $X=660 $Y=345 $D=0
M1 ZN A1 6 VSS N L=1.8e-07 W=1e-06 $X=1385 $Y=345 $D=0
M2 ZN A2 VDD VDD P L=1.8e-07 W=1.37e-06 $X=660 $Y=2205 $D=16
M3 VDD A1 ZN VDD P L=1.8e-07 W=1.37e-06 $X=1385 $Y=2205 $D=16
.ENDS
***************************************
.SUBCKT AN3D1BWP7T A1 A2 A3 VDD Z VSS
** N=10 EP=6 IP=0 FDC=8
M0 9 A1 7 VSS N L=1.8e-07 W=5e-07 $X=620 $Y=345 $D=0
M1 10 A2 9 VSS N L=1.8e-07 W=5e-07 $X=1205 $Y=345 $D=0
M2 VSS A3 10 VSS N L=1.8e-07 W=5e-07 $X=1790 $Y=345 $D=0
M3 Z 7 VSS VSS N L=1.8e-07 W=1e-06 $X=2560 $Y=345 $D=0
M4 VDD A1 7 VDD P L=1.8e-07 W=6.85e-07 $X=620 $Y=2205 $D=16
M5 7 A2 VDD VDD P L=1.8e-07 W=6.85e-07 $X=1230 $Y=2205 $D=16
M6 VDD A3 7 VDD P L=1.8e-07 W=6.85e-07 $X=1950 $Y=2205 $D=16
M7 Z 7 VDD VDD P L=1.8e-07 W=1.37e-06 $X=2560 $Y=2205 $D=16
.ENDS
***************************************
.SUBCKT ICV_115
** N=2 EP=0 IP=4 FDC=0
.ENDS
***************************************
.SUBCKT ICV_116
** N=2 EP=0 IP=4 FDC=0
.ENDS
***************************************
.SUBCKT OAI211D1BWP7T C B A1 A2 VDD ZN VSS
** N=10 EP=7 IP=0 FDC=8
M0 10 C VSS VSS N L=1.8e-07 W=1e-06 $X=620 $Y=345 $D=0
M1 9 B 10 VSS N L=1.8e-07 W=1e-06 $X=1120 $Y=345 $D=0
M2 ZN A1 9 VSS N L=1.8e-07 W=1e-06 $X=1840 $Y=345 $D=0
M3 9 A2 ZN VSS N L=1.8e-07 W=1e-06 $X=2560 $Y=345 $D=0
M4 ZN C VDD VDD P L=1.8e-07 W=1.37e-06 $X=620 $Y=2205 $D=16
M5 VDD B ZN VDD P L=1.8e-07 W=1.37e-06 $X=1340 $Y=2205 $D=16
M6 8 A1 VDD VDD P L=1.8e-07 W=1.37e-06 $X=2060 $Y=2205 $D=16
M7 ZN A2 8 VDD P L=1.8e-07 W=1.37e-06 $X=2560 $Y=2205 $D=16
.ENDS
***************************************
.SUBCKT ICV_117 1 2 3 4 5
*.CALIBRE ICV_CELL 9
** N=5 EP=5 IP=7 FDC=6
X1 3 5 2 4 1 INR2D1BWP7T $T=0 0 0 0 $X=-290 $Y=-235
.ENDS
***************************************
.SUBCKT ICV_118 1 2 3 4 5 6 7
*.CALIBRE ICV_CELL 9
** N=7 EP=7 IP=9 FDC=8
X1 4 1 6 7 3 5 2 AOI22D0BWP7T $T=0 0 0 0 $X=-290 $Y=-235
.ENDS
***************************************
.SUBCKT IND4D0BWP7T A1 B1 B2 B3 ZN VDD VSS
** N=13 EP=7 IP=0 FDC=10
M0 VSS A1 8 VSS N L=1.8e-07 W=4.2e-07 $X=620 $Y=425 $D=0
M1 11 8 VSS VSS N L=1.8e-07 W=5e-07 $X=1340 $Y=345 $D=0
M2 12 B1 11 VSS N L=1.8e-07 W=5e-07 $X=1930 $Y=345 $D=0
M3 13 B2 12 VSS N L=1.8e-07 W=5e-07 $X=2520 $Y=345 $D=0
M4 ZN B3 13 VSS N L=1.8e-07 W=5e-07 $X=3110 $Y=345 $D=0
M5 VDD A1 8 VDD P L=1.8e-07 W=4.2e-07 $X=620 $Y=2845 $D=16
M6 ZN 8 VDD VDD P L=1.8e-07 W=6.85e-07 $X=1220 $Y=2320 $D=16
M7 VDD B1 ZN VDD P L=1.8e-07 W=6.85e-07 $X=1940 $Y=2320 $D=16
M8 ZN B2 VDD VDD P L=1.8e-07 W=6.85e-07 $X=2540 $Y=2320 $D=16
M9 VDD B3 ZN VDD P L=1.8e-07 W=6.85e-07 $X=3260 $Y=2320 $D=16
.ENDS
***************************************
.SUBCKT ND4D0BWP7T A4 A3 A2 A1 VDD ZN VSS
** N=11 EP=7 IP=0 FDC=8
M0 9 A4 VSS VSS N L=1.8e-07 W=5e-07 $X=620 $Y=360 $D=0
M1 10 A3 9 VSS N L=1.8e-07 W=5e-07 $X=1240 $Y=360 $D=0
M2 11 A2 10 VSS N L=1.8e-07 W=5e-07 $X=1860 $Y=360 $D=0
M3 ZN A1 11 VSS N L=1.8e-07 W=5e-07 $X=2480 $Y=360 $D=0
M4 ZN A4 VDD VDD P L=1.8e-07 W=6.85e-07 $X=575 $Y=2235 $D=16
M5 VDD A3 ZN VDD P L=1.8e-07 W=6.85e-07 $X=1295 $Y=2235 $D=16
M6 ZN A2 VDD VDD P L=1.8e-07 W=6.85e-07 $X=1955 $Y=2235 $D=16
M7 VDD A1 ZN VDD P L=1.8e-07 W=6.85e-07 $X=2690 $Y=2235 $D=16
.ENDS
***************************************
.SUBCKT MOAI22D0BWP7T B1 B2 A1 A2 ZN VDD VSS
** N=13 EP=7 IP=0 FDC=10
M0 12 B1 8 VSS N L=1.8e-07 W=5e-07 $X=620 $Y=610 $D=0
M1 VSS B2 12 VSS N L=1.8e-07 W=5e-07 $X=1050 $Y=610 $D=0
M2 13 8 VSS VSS N L=1.8e-07 W=5e-07 $X=1850 $Y=610 $D=0
M3 ZN A1 13 VSS N L=1.8e-07 W=5e-07 $X=2560 $Y=845 $D=0
M4 13 A2 ZN VSS N L=1.8e-07 W=5e-07 $X=3280 $Y=845 $D=0
M5 8 B1 VDD VDD P L=1.8e-07 W=6.85e-07 $X=460 $Y=2390 $D=16
M6 VDD B2 8 VDD P L=1.8e-07 W=6.85e-07 $X=1180 $Y=2390 $D=16
M7 ZN 8 VDD VDD P L=1.8e-07 W=6.85e-07 $X=1980 $Y=2390 $D=16
M8 9 A1 ZN VDD P L=1.8e-07 W=6.85e-07 $X=2700 $Y=2390 $D=16
M9 VDD A2 9 VDD P L=1.8e-07 W=6.85e-07 $X=3280 $Y=2390 $D=16
.ENDS
***************************************
.SUBCKT ND3D0BWP7T A3 A2 A1 VDD ZN VSS
** N=9 EP=6 IP=0 FDC=6
M0 8 A3 VSS VSS N L=1.8e-07 W=5e-07 $X=620 $Y=500 $D=0
M1 9 A2 8 VSS N L=1.8e-07 W=5e-07 $X=1245 $Y=500 $D=0
M2 ZN A1 9 VSS N L=1.8e-07 W=5e-07 $X=1870 $Y=500 $D=0
M3 ZN A3 VDD VDD P L=1.8e-07 W=6.85e-07 $X=620 $Y=2735 $D=16
M4 VDD A2 ZN VDD P L=1.8e-07 W=6.85e-07 $X=1340 $Y=2735 $D=16
M5 ZN A1 VDD VDD P L=1.8e-07 W=6.85e-07 $X=2000 $Y=2205 $D=16
.ENDS
***************************************
.SUBCKT AO211D0BWP7T A1 A2 B C VDD Z VSS
** N=12 EP=7 IP=0 FDC=10
M0 12 A1 8 VSS N L=1.8e-07 W=5e-07 $X=620 $Y=845 $D=0
M1 VSS A2 12 VSS N L=1.8e-07 W=5e-07 $X=1050 $Y=845 $D=0
M2 8 B VSS VSS N L=1.8e-07 W=5e-07 $X=1780 $Y=880 $D=0
M3 VSS C 8 VSS N L=1.8e-07 W=5e-07 $X=2500 $Y=880 $D=0
M4 Z 8 VSS VSS N L=1.8e-07 W=5e-07 $X=3120 $Y=580 $D=0
M5 8 A1 9 VDD P L=1.8e-07 W=6.85e-07 $X=570 $Y=2395 $D=16
M6 9 A2 8 VDD P L=1.8e-07 W=6.85e-07 $X=1290 $Y=2395 $D=16
M7 10 B 9 VDD P L=1.8e-07 W=6.85e-07 $X=1970 $Y=2790 $D=16
M8 VDD C 10 VDD P L=1.8e-07 W=6.85e-07 $X=2400 $Y=2790 $D=16
M9 Z 8 VDD VDD P L=1.8e-07 W=6.85e-07 $X=3120 $Y=2790 $D=16
.ENDS
***************************************
.SUBCKT DFD1BWP7T CP D VDD QN VSS
** N=18 EP=5 IP=0 FDC=26
M0 VSS CP 9 VSS N L=1.8e-07 W=5e-07 $X=640 $Y=840 $D=0
M1 6 9 VSS VSS N L=1.8e-07 W=5e-07 $X=1240 $Y=840 $D=0
M2 17 9 VSS VSS N L=1.8e-07 W=9.4e-07 $X=2665 $Y=405 $D=0
M3 8 D 17 VSS N L=1.8e-07 W=9.4e-07 $X=3135 $Y=405 $D=0
M4 18 6 8 VSS N L=1.8e-07 W=4.2e-07 $X=3990 $Y=895 $D=0
M5 VSS 7 18 VSS N L=1.8e-07 W=4.2e-07 $X=4485 $Y=895 $D=0
M6 7 8 VSS VSS N L=1.8e-07 W=5.4e-07 $X=5285 $Y=775 $D=0
M7 11 6 7 VSS N L=1.8e-07 W=9.1e-07 $X=6005 $Y=405 $D=0
M8 12 9 11 VSS N L=1.8e-07 W=4.2e-07 $X=6725 $Y=895 $D=0
M9 VSS 10 12 VSS N L=1.8e-07 W=5e-07 $X=7445 $Y=845 $D=0
M10 10 11 VSS VSS N L=1.8e-07 W=1e-06 $X=8045 $Y=345 $D=0
M11 VSS 12 QN VSS N L=1.8e-07 W=9.4e-07 $X=9680 $Y=405 $D=0
M12 Q 10 VSS VSS N L=1.8e-07 W=1e-06 $X=10400 $Y=345 $D=0
M13 VDD CP 9 VDD P L=1.8e-07 W=6.85e-07 $X=620 $Y=2345 $D=16
M14 6 9 VDD VDD P L=1.8e-07 W=6.85e-07 $X=1240 $Y=2345 $D=16
M15 13 6 VDD VDD P L=1.8e-07 W=9.2e-07 $X=2705 $Y=2205 $D=16
M16 8 D 13 VDD P L=1.8e-07 W=9.2e-07 $X=3205 $Y=2205 $D=16
M17 14 9 8 VDD P L=1.8e-07 W=4.2e-07 $X=3985 $Y=2705 $D=16
M18 VDD 7 14 VDD P L=1.8e-07 W=4.2e-07 $X=4485 $Y=2705 $D=16
M19 7 8 VDD VDD P L=1.8e-07 W=9.6e-07 $X=5285 $Y=2175 $D=16
M20 11 9 7 VDD P L=1.8e-07 W=1.34e-06 $X=6005 $Y=2175 $D=16
M21 12 6 11 VDD P L=1.8e-07 W=4.2e-07 $X=6725 $Y=2470 $D=16
M22 VDD 10 12 VDD P L=1.8e-07 W=6.85e-07 $X=7485 $Y=2205 $D=16
M23 10 11 VDD VDD P L=1.8e-07 W=1.37e-06 $X=8255 $Y=2205 $D=16
M24 VDD 12 QN VDD P L=1.8e-07 W=1.37e-06 $X=9680 $Y=2205 $D=16
M25 Q 10 VDD VDD P L=1.8e-07 W=1.37e-06 $X=10400 $Y=2205 $D=16
.ENDS
***************************************
.SUBCKT ICV_119
** N=2 EP=0 IP=4 FDC=0
.ENDS
***************************************
.SUBCKT DFCNQD1BWP7T CP D CDN VDD Q VSS
** N=21 EP=6 IP=0 FDC=28
M0 VSS CP 8 VSS N L=1.8e-07 W=5e-07 $X=640 $Y=840 $D=0
M1 7 8 VSS VSS N L=1.8e-07 W=5e-07 $X=1240 $Y=840 $D=0
M2 18 8 VSS VSS N L=1.8e-07 W=9.4e-07 $X=2660 $Y=405 $D=0
M3 10 D 18 VSS N L=1.8e-07 W=9.4e-07 $X=3160 $Y=405 $D=0
M4 19 7 10 VSS N L=1.8e-07 W=4.2e-07 $X=4005 $Y=895 $D=0
M5 20 CDN 19 VSS N L=1.8e-07 W=4.2e-07 $X=4435 $Y=895 $D=0
M6 VSS 9 20 VSS N L=1.8e-07 W=4.2e-07 $X=4865 $Y=895 $D=0
M7 9 10 VSS VSS N L=1.8e-07 W=5.4e-07 $X=5715 $Y=775 $D=0
M8 12 7 9 VSS N L=1.8e-07 W=9.1e-07 $X=6435 $Y=405 $D=0
M9 15 8 12 VSS N L=1.8e-07 W=4.2e-07 $X=7255 $Y=895 $D=0
M10 VSS 11 15 VSS N L=1.8e-07 W=4.2e-07 $X=8915 $Y=895 $D=0
M11 21 CDN VSS VSS N L=1.8e-07 W=9.7e-07 $X=9610 $Y=345 $D=0
M12 11 12 21 VSS N L=1.8e-07 W=9.7e-07 $X=10055 $Y=345 $D=0
M13 Q 11 VSS VSS N L=1.8e-07 W=1e-06 $X=11520 $Y=345 $D=0
M14 VDD CP 8 VDD P L=1.8e-07 W=6.85e-07 $X=620 $Y=2345 $D=16
M15 7 8 VDD VDD P L=1.8e-07 W=6.85e-07 $X=1240 $Y=2345 $D=16
M16 13 7 VDD VDD P L=1.8e-07 W=1.37e-06 $X=2525 $Y=2205 $D=16
M17 10 D 13 VDD P L=1.8e-07 W=1.37e-06 $X=2955 $Y=2205 $D=16
M18 14 8 10 VDD P L=1.8e-07 W=4.2e-07 $X=3795 $Y=2365 $D=16
M19 VDD CDN 14 VDD P L=1.8e-07 W=4.2e-07 $X=4515 $Y=2365 $D=16
M20 14 9 VDD VDD P L=1.8e-07 W=4.2e-07 $X=5115 $Y=2365 $D=16
M21 9 10 VDD VDD P L=1.8e-07 W=6.2e-07 $X=6375 $Y=2175 $D=16
M22 12 8 9 VDD P L=1.8e-07 W=6.2e-07 $X=7255 $Y=2175 $D=16
M23 15 7 12 VDD P L=1.8e-07 W=4.2e-07 $X=8080 $Y=2175 $D=16
M24 VDD 11 15 VDD P L=1.8e-07 W=4.2e-07 $X=8915 $Y=2175 $D=16
M25 11 CDN VDD VDD P L=1.8e-07 W=4.2e-07 $X=9850 $Y=3095 $D=16
M26 VDD 12 11 VDD P L=1.8e-07 W=1.37e-06 $X=10680 $Y=2205 $D=16
M27 Q 11 VDD VDD P L=1.8e-07 W=1.37e-06 $X=11520 $Y=2205 $D=16
.ENDS
***************************************
.SUBCKT ICV_120 1 2 3 4 5 6 7
*.CALIBRE ICV_CELL 9
** N=7 EP=7 IP=9 FDC=10
X1 4 5 1 7 6 3 2 MOAI22D0BWP7T $T=0 0 0 0 $X=-290 $Y=-235
.ENDS
***************************************
.SUBCKT ICV_121 1 2 3 4 5 6 7
*.CALIBRE ICV_CELL 9
** N=7 EP=7 IP=9 FDC=8
X1 5 1 2 6 4 7 3 ND4D0BWP7T $T=0 0 0 0 $X=-290 $Y=-235
.ENDS
***************************************
.SUBCKT ICV_122
** N=2 EP=0 IP=4 FDC=0
.ENDS
***************************************
.SUBCKT DFCND1BWP7T CP D CDN VDD QN VSS
** N=23 EP=6 IP=0 FDC=30
M0 VSS CP 8 VSS N L=1.8e-07 W=5e-07 $X=640 $Y=840 $D=0
M1 7 8 VSS VSS N L=1.8e-07 W=5e-07 $X=1240 $Y=840 $D=0
M2 20 8 VSS VSS N L=1.8e-07 W=9.4e-07 $X=2660 $Y=405 $D=0
M3 10 D 20 VSS N L=1.8e-07 W=9.4e-07 $X=3160 $Y=405 $D=0
M4 21 7 10 VSS N L=1.8e-07 W=4.2e-07 $X=4005 $Y=895 $D=0
M5 22 CDN 21 VSS N L=1.8e-07 W=4.2e-07 $X=4435 $Y=895 $D=0
M6 VSS 9 22 VSS N L=1.8e-07 W=4.2e-07 $X=4865 $Y=895 $D=0
M7 9 10 VSS VSS N L=1.8e-07 W=5.4e-07 $X=5715 $Y=775 $D=0
M8 12 7 9 VSS N L=1.8e-07 W=9.1e-07 $X=6435 $Y=405 $D=0
M9 13 8 12 VSS N L=1.8e-07 W=4.2e-07 $X=7155 $Y=895 $D=0
M10 VSS 11 13 VSS N L=1.8e-07 W=4.2e-07 $X=8730 $Y=895 $D=0
M11 23 CDN VSS VSS N L=1.8e-07 W=9.7e-07 $X=9330 $Y=345 $D=0
M12 11 12 23 VSS N L=1.8e-07 W=9.7e-07 $X=9760 $Y=345 $D=0
M13 VSS 13 QN VSS N L=1.8e-07 W=9.4e-07 $X=11360 $Y=405 $D=0
M14 Q 11 VSS VSS N L=1.8e-07 W=1e-06 $X=12080 $Y=345 $D=0
M15 VDD CP 8 VDD P L=1.8e-07 W=6.85e-07 $X=620 $Y=2345 $D=16
M16 7 8 VDD VDD P L=1.8e-07 W=6.85e-07 $X=1240 $Y=2345 $D=16
M17 14 7 VDD VDD P L=1.8e-07 W=1.37e-06 $X=2525 $Y=2205 $D=16
M18 10 D 14 VDD P L=1.8e-07 W=1.37e-06 $X=2955 $Y=2205 $D=16
M19 15 8 10 VDD P L=1.8e-07 W=4.2e-07 $X=3795 $Y=2365 $D=16
M20 VDD CDN 15 VDD P L=1.8e-07 W=4.2e-07 $X=4515 $Y=2365 $D=16
M21 15 9 VDD VDD P L=1.8e-07 W=4.2e-07 $X=5115 $Y=2365 $D=16
M22 9 10 VDD VDD P L=1.8e-07 W=6.2e-07 $X=6375 $Y=2175 $D=16
M23 12 8 9 VDD P L=1.8e-07 W=6.2e-07 $X=7255 $Y=2175 $D=16
M24 13 7 12 VDD P L=1.8e-07 W=4.2e-07 $X=8070 $Y=2175 $D=16
M25 VDD 11 13 VDD P L=1.8e-07 W=6e-07 $X=8790 $Y=2175 $D=16
M26 11 CDN VDD VDD P L=1.8e-07 W=4.2e-07 $X=9390 $Y=3095 $D=16
M27 VDD 12 11 VDD P L=1.8e-07 W=1.37e-06 $X=10150 $Y=2205 $D=16
M28 VDD 13 QN VDD P L=1.8e-07 W=8.35e-07 $X=11410 $Y=2205 $D=16
M29 Q 11 VDD VDD P L=1.8e-07 W=1.37e-06 $X=12080 $Y=2205 $D=16
.ENDS
***************************************
.SUBCKT DEL01BWP7T I VDD Z VSS
** N=5 EP=4 IP=0 FDC=4
M0 VSS I 5 VSS N L=1.8e-07 W=1e-06 $X=625 $Y=345 $D=0
M1 Z 5 VSS VSS N L=1.8e-07 W=1e-06 $X=1345 $Y=345 $D=0
M2 VDD I 5 VDD P L=1.8e-07 W=1.37e-06 $X=625 $Y=2205 $D=16
M3 Z 5 VDD VDD P L=1.8e-07 W=1.37e-06 $X=1345 $Y=2205 $D=16
.ENDS
***************************************
.SUBCKT ICV_123 1 2 3 4 5 6 7
*.CALIBRE ICV_CELL 9
** N=7 EP=7 IP=9 FDC=8
X1 4 1 6 7 3 5 2 AOI22D0BWP7T $T=0 0 0 0 $X=-290 $Y=-235
.ENDS
***************************************
.SUBCKT OAI21D0BWP7T A2 A1 B VDD ZN VSS
** N=8 EP=6 IP=0 FDC=6
M0 ZN A2 8 VSS N L=1.8e-07 W=5e-07 $X=620 $Y=845 $D=0
M1 8 A1 ZN VSS N L=1.8e-07 W=5e-07 $X=1340 $Y=845 $D=0
M2 VSS B 8 VSS N L=1.8e-07 W=4.65e-07 $X=2060 $Y=880 $D=0
M3 7 A2 VDD VDD P L=1.8e-07 W=6.85e-07 $X=620 $Y=2770 $D=16
M4 ZN A1 7 VDD P L=1.8e-07 W=6.85e-07 $X=1250 $Y=2770 $D=16
M5 VDD B ZN VDD P L=1.8e-07 W=6.85e-07 $X=1975 $Y=2770 $D=16
.ENDS
***************************************
.SUBCKT DFKSND1BWP7T SN D CP VDD Q VSS
** N=20 EP=6 IP=0 FDC=30
M0 VSS SN 7 VSS N L=1.8e-07 W=5e-07 $X=620 $Y=845 $D=0
M1 16 7 VSS VSS N L=1.8e-07 W=5e-07 $X=1420 $Y=845 $D=0
M2 VSS D 16 VSS N L=1.8e-07 W=1e-06 $X=2180 $Y=345 $D=0
M3 VSS CP 11 VSS N L=1.8e-07 W=5e-07 $X=3490 $Y=980 $D=0
M4 10 11 VSS VSS N L=1.8e-07 W=5e-07 $X=4090 $Y=840 $D=0
M5 9 11 16 VSS N L=1.8e-07 W=9.4e-07 $X=5535 $Y=405 $D=0
M6 20 10 9 VSS N L=1.8e-07 W=4.2e-07 $X=6260 $Y=895 $D=0
M7 VSS 8 20 VSS N L=1.8e-07 W=4.2e-07 $X=6725 $Y=895 $D=0
M8 8 9 VSS VSS N L=1.8e-07 W=5.4e-07 $X=7525 $Y=775 $D=0
M9 13 10 8 VSS N L=1.8e-07 W=9.1e-07 $X=8245 $Y=405 $D=0
M10 14 11 13 VSS N L=1.8e-07 W=4.2e-07 $X=8965 $Y=895 $D=0
M11 VSS 12 14 VSS N L=1.8e-07 W=5e-07 $X=9685 $Y=845 $D=0
M12 12 13 VSS VSS N L=1.8e-07 W=1e-06 $X=10285 $Y=345 $D=0
M13 VSS 14 QN VSS N L=1.8e-07 W=9.4e-07 $X=11920 $Y=405 $D=0
M14 Q 12 VSS VSS N L=1.8e-07 W=1e-06 $X=12640 $Y=345 $D=0
M15 VDD SN 7 VDD P L=1.8e-07 W=6.85e-07 $X=620 $Y=2205 $D=16
M16 15 7 VDD VDD P L=1.8e-07 W=1.37e-06 $X=1420 $Y=2205 $D=16
M17 16 D 15 VDD P L=1.8e-07 W=1.37e-06 $X=1880 $Y=2205 $D=16
M18 VDD CP 11 VDD P L=1.8e-07 W=6.85e-07 $X=3435 $Y=2345 $D=16
M19 10 11 VDD VDD P L=1.8e-07 W=6.85e-07 $X=4090 $Y=2345 $D=16
M20 9 10 16 VDD P L=1.8e-07 W=9.2e-07 $X=5535 $Y=2205 $D=16
M21 17 11 9 VDD P L=1.8e-07 W=4.2e-07 $X=6295 $Y=2705 $D=16
M22 VDD 8 17 VDD P L=1.8e-07 W=4.2e-07 $X=6725 $Y=2705 $D=16
M23 8 9 VDD VDD P L=1.8e-07 W=9.6e-07 $X=7525 $Y=2175 $D=16
M24 13 11 8 VDD P L=1.8e-07 W=1.34e-06 $X=8245 $Y=2175 $D=16
M25 14 10 13 VDD P L=1.8e-07 W=4.2e-07 $X=8965 $Y=2470 $D=16
M26 VDD 12 14 VDD P L=1.8e-07 W=6.85e-07 $X=9725 $Y=2205 $D=16
M27 12 13 VDD VDD P L=1.8e-07 W=1.37e-06 $X=10495 $Y=2205 $D=16
M28 VDD 14 QN VDD P L=1.8e-07 W=1.37e-06 $X=11920 $Y=2205 $D=16
M29 Q 12 VDD VDD P L=1.8e-07 W=1.37e-06 $X=12640 $Y=2205 $D=16
.ENDS
***************************************
.SUBCKT AOI211XD0BWP7T C B A2 A1 VDD ZN VSS
** N=10 EP=7 IP=0 FDC=8
M0 ZN C VSS VSS N L=1.8e-07 W=5e-07 $X=620 $Y=680 $D=0
M1 VSS B ZN VSS N L=1.8e-07 W=5e-07 $X=1340 $Y=680 $D=0
M2 10 A2 VSS VSS N L=1.8e-07 W=5e-07 $X=2060 $Y=680 $D=0
M3 ZN A1 10 VSS N L=1.8e-07 W=5e-07 $X=2560 $Y=680 $D=0
M4 8 C VDD VDD P L=1.8e-07 W=1.37e-06 $X=620 $Y=2205 $D=16
M5 9 B 8 VDD P L=1.8e-07 W=1.37e-06 $X=1100 $Y=2205 $D=16
M6 ZN A2 9 VDD P L=1.8e-07 W=1.37e-06 $X=1830 $Y=2205 $D=16
M7 9 A1 ZN VDD P L=1.8e-07 W=1.37e-06 $X=2560 $Y=2205 $D=16
.ENDS
***************************************
.SUBCKT BUFFD1P5BWP7T I VDD Z VSS
** N=5 EP=4 IP=0 FDC=6
M0 VSS I 5 VSS N L=1.8e-07 W=1e-06 $X=620 $Y=345 $D=0
M1 Z 5 VSS VSS N L=1.8e-07 W=1e-06 $X=1340 $Y=345 $D=0
M2 VSS 5 Z VSS N L=1.8e-07 W=4.65e-07 $X=2060 $Y=880 $D=0
M3 VDD I 5 VDD P L=1.8e-07 W=1.37e-06 $X=620 $Y=2205 $D=16
M4 Z 5 VDD VDD P L=1.8e-07 W=1.37e-06 $X=1340 $Y=2205 $D=16
M5 VDD 5 Z VDD P L=1.8e-07 W=6.85e-07 $X=2060 $Y=2205 $D=16
.ENDS
***************************************
.SUBCKT ICV_124
** N=2 EP=0 IP=4 FDC=0
.ENDS
***************************************
.SUBCKT ICV_125 1 2 3 4 5
*.CALIBRE ICV_CELL 9
** N=5 EP=5 IP=7 FDC=4
X1 3 5 2 4 1 ND2D1BWP7T $T=1680 0 0 0 $X=1390 $Y=-235
.ENDS
***************************************
.SUBCKT ICV_126
** N=2 EP=0 IP=4 FDC=0
.ENDS
***************************************
.SUBCKT IND2D2BWP7T A1 B1 VDD ZN VSS
** N=8 EP=5 IP=0 FDC=10
M0 VSS A1 6 VSS N L=1.8e-07 W=1e-06 $X=620 $Y=345 $D=0
M1 7 6 VSS VSS N L=1.8e-07 W=1e-06 $X=1420 $Y=345 $D=0
M2 ZN B1 7 VSS N L=1.8e-07 W=1e-06 $X=2060 $Y=345 $D=0
M3 8 B1 ZN VSS N L=1.8e-07 W=1e-06 $X=2780 $Y=345 $D=0
M4 VSS 6 8 VSS N L=1.8e-07 W=1e-06 $X=3380 $Y=345 $D=0
M5 VDD A1 6 VDD P L=1.8e-07 W=1.37e-06 $X=620 $Y=2205 $D=16
M6 ZN 6 VDD VDD P L=1.8e-07 W=1.37e-06 $X=1340 $Y=2205 $D=16
M7 VDD B1 ZN VDD P L=1.8e-07 W=1.37e-06 $X=2060 $Y=2205 $D=16
M8 ZN B1 VDD VDD P L=1.8e-07 W=1.37e-06 $X=2780 $Y=2205 $D=16
M9 VDD 6 ZN VDD P L=1.8e-07 W=1.37e-06 $X=3500 $Y=2205 $D=16
.ENDS
***************************************
.SUBCKT DFD0BWP7T CP D VDD QN VSS
** N=18 EP=5 IP=0 FDC=26
M0 VSS CP 9 VSS N L=1.8e-07 W=5e-07 $X=640 $Y=840 $D=0
M1 6 9 VSS VSS N L=1.8e-07 W=5e-07 $X=1240 $Y=840 $D=0
M2 17 9 VSS VSS N L=1.8e-07 W=9.4e-07 $X=2665 $Y=405 $D=0
M3 8 D 17 VSS N L=1.8e-07 W=9.4e-07 $X=3135 $Y=405 $D=0
M4 18 6 8 VSS N L=1.8e-07 W=4.2e-07 $X=3990 $Y=895 $D=0
M5 VSS 7 18 VSS N L=1.8e-07 W=4.2e-07 $X=4485 $Y=895 $D=0
M6 7 8 VSS VSS N L=1.8e-07 W=5.4e-07 $X=5285 $Y=775 $D=0
M7 11 6 7 VSS N L=1.8e-07 W=9.1e-07 $X=6005 $Y=405 $D=0
M8 12 9 11 VSS N L=1.8e-07 W=4.2e-07 $X=6725 $Y=895 $D=0
M9 VSS 10 12 VSS N L=1.8e-07 W=5e-07 $X=7445 $Y=845 $D=0
M10 10 11 VSS VSS N L=1.8e-07 W=5e-07 $X=8045 $Y=845 $D=0
M11 VSS 12 QN VSS N L=1.8e-07 W=5e-07 $X=9680 $Y=445 $D=0
M12 Q 10 VSS VSS N L=1.8e-07 W=5e-07 $X=10400 $Y=445 $D=0
M13 VDD CP 9 VDD P L=1.8e-07 W=6.85e-07 $X=620 $Y=2345 $D=16
M14 6 9 VDD VDD P L=1.8e-07 W=6.85e-07 $X=1240 $Y=2345 $D=16
M15 13 6 VDD VDD P L=1.8e-07 W=9.2e-07 $X=2705 $Y=2205 $D=16
M16 8 D 13 VDD P L=1.8e-07 W=9.2e-07 $X=3205 $Y=2205 $D=16
M17 14 9 8 VDD P L=1.8e-07 W=4.2e-07 $X=3985 $Y=2705 $D=16
M18 VDD 7 14 VDD P L=1.8e-07 W=4.2e-07 $X=4485 $Y=2705 $D=16
M19 7 8 VDD VDD P L=1.8e-07 W=9.6e-07 $X=5285 $Y=2175 $D=16
M20 11 9 7 VDD P L=1.8e-07 W=1.34e-06 $X=6005 $Y=2175 $D=16
M21 12 6 11 VDD P L=1.8e-07 W=4.2e-07 $X=6725 $Y=2470 $D=16
M22 VDD 10 12 VDD P L=1.8e-07 W=6.85e-07 $X=7485 $Y=2205 $D=16
M23 10 11 VDD VDD P L=1.8e-07 W=6.85e-07 $X=8255 $Y=2890 $D=16
M24 VDD 12 QN VDD P L=1.8e-07 W=6.85e-07 $X=9680 $Y=2205 $D=16
M25 Q 10 VDD VDD P L=1.8e-07 W=6.85e-07 $X=10400 $Y=2205 $D=16
.ENDS
***************************************
.SUBCKT AN4D0BWP7T A1 A2 A3 A4 VDD Z VSS
** N=13 EP=7 IP=0 FDC=10
M0 11 A1 8 VSS N L=1.8e-07 W=5e-07 $X=625 $Y=345 $D=0
M1 12 A2 11 VSS N L=1.8e-07 W=5e-07 $X=1205 $Y=345 $D=0
M2 13 A3 12 VSS N L=1.8e-07 W=5e-07 $X=1785 $Y=345 $D=0
M3 VSS A4 13 VSS N L=1.8e-07 W=5e-07 $X=2365 $Y=345 $D=0
M4 Z 8 VSS VSS N L=1.8e-07 W=5e-07 $X=3105 $Y=345 $D=0
M5 8 A1 VDD VDD P L=1.8e-07 W=6.85e-07 $X=460 $Y=2205 $D=16
M6 VDD A2 8 VDD P L=1.8e-07 W=6.85e-07 $X=1185 $Y=2205 $D=16
M7 8 A3 VDD VDD P L=1.8e-07 W=6.85e-07 $X=1785 $Y=2205 $D=16
M8 VDD A4 8 VDD P L=1.8e-07 W=6.85e-07 $X=2515 $Y=2205 $D=16
M9 Z 8 VDD VDD P L=1.8e-07 W=6.85e-07 $X=3115 $Y=2205 $D=16
.ENDS
***************************************
.SUBCKT AO22D0BWP7T B2 B1 A1 A2 VDD Z VSS
** N=12 EP=7 IP=0 FDC=10
M0 11 B2 VSS VSS N L=1.8e-07 W=5e-07 $X=620 $Y=460 $D=0
M1 8 B1 11 VSS N L=1.8e-07 W=5e-07 $X=1115 $Y=460 $D=0
M2 12 A1 8 VSS N L=1.8e-07 W=5e-07 $X=1915 $Y=460 $D=0
M3 VSS A2 12 VSS N L=1.8e-07 W=5e-07 $X=2475 $Y=460 $D=0
M4 Z 8 VSS VSS N L=1.8e-07 W=5e-07 $X=3675 $Y=460 $D=0
M5 9 B2 VDD VDD P L=1.8e-07 W=6.85e-07 $X=620 $Y=2670 $D=16
M6 8 A1 9 VDD P L=1.8e-07 W=6.85e-07 $X=1415 $Y=2670 $D=16
M7 9 A2 8 VDD P L=1.8e-07 W=6.85e-07 $X=2235 $Y=2670 $D=16
M8 VDD B1 9 VDD P L=1.8e-07 W=6.85e-07 $X=2955 $Y=2670 $D=16
M9 Z 8 VDD VDD P L=1.8e-07 W=6.85e-07 $X=3675 $Y=2670 $D=16
.ENDS
***************************************
.SUBCKT ICV_127
** N=2 EP=0 IP=4 FDC=0
.ENDS
***************************************
.SUBCKT OR3D1BWP7T A3 A2 A1 VDD Z VSS
** N=10 EP=6 IP=0 FDC=8
M0 VSS A3 7 VSS N L=1.8e-07 W=5e-07 $X=620 $Y=345 $D=0
M1 7 A2 VSS VSS N L=1.8e-07 W=5e-07 $X=1420 $Y=345 $D=0
M2 VSS A1 7 VSS N L=1.8e-07 W=5e-07 $X=2140 $Y=345 $D=0
M3 Z 7 VSS VSS N L=1.8e-07 W=1e-06 $X=2945 $Y=345 $D=0
M4 8 A3 7 VDD P L=1.8e-07 W=1.37e-06 $X=620 $Y=2205 $D=16
M5 9 A2 8 VDD P L=1.8e-07 W=1.37e-06 $X=1220 $Y=2205 $D=16
M6 VDD A1 9 VDD P L=1.8e-07 W=1.37e-06 $X=1820 $Y=2205 $D=16
M7 Z 7 VDD VDD P L=1.8e-07 W=1.37e-06 $X=2620 $Y=2205 $D=16
.ENDS
***************************************
.SUBCKT OA221D0BWP7T B1 A1 A2 B2 C VDD Z VSS
** N=13 EP=8 IP=0 FDC=12
M0 13 B1 12 VSS N L=1.8e-07 W=5e-07 $X=640 $Y=345 $D=0
M1 9 A1 13 VSS N L=1.8e-07 W=5e-07 $X=1260 $Y=750 $D=0
M2 13 A2 9 VSS N L=1.8e-07 W=5e-07 $X=1980 $Y=750 $D=0
M3 12 B2 13 VSS N L=1.8e-07 W=5e-07 $X=2680 $Y=750 $D=0
M4 VSS C 12 VSS N L=1.8e-07 W=5e-07 $X=3440 $Y=345 $D=0
M5 Z 9 VSS VSS N L=1.8e-07 W=5e-07 $X=4160 $Y=345 $D=0
M6 10 A1 9 VDD P L=1.8e-07 W=6.85e-07 $X=680 $Y=2890 $D=16
M7 VDD A2 10 VDD P L=1.8e-07 W=6.85e-07 $X=1280 $Y=2890 $D=16
M8 11 B1 VDD VDD P L=1.8e-07 W=6.85e-07 $X=2140 $Y=2890 $D=16
M9 9 B2 11 VDD P L=1.8e-07 W=6.85e-07 $X=2720 $Y=2890 $D=16
M10 VDD C 9 VDD P L=1.8e-07 W=6.85e-07 $X=3440 $Y=2890 $D=16
M11 Z 9 VDD VDD P L=1.8e-07 W=6.85e-07 $X=4240 $Y=2890 $D=16
.ENDS
***************************************
.SUBCKT ICV_128 1 2 3 4 5
*.CALIBRE ICV_CELL 9
** N=5 EP=5 IP=7 FDC=6
X1 3 5 2 4 1 INR2D1BWP7T $T=0 0 0 0 $X=-290 $Y=-235
.ENDS
***************************************
.SUBCKT ICV_129 1 2 3 4 5 6
*.CALIBRE ICV_CELL 9
** N=6 EP=6 IP=8 FDC=26
X1 5 1 2 4 6 3 DFKCNQD1BWP7T $T=0 0 0 0 $X=-290 $Y=-235
.ENDS
***************************************
.SUBCKT NR3D0BWP7T A3 A2 A1 VDD ZN VSS
** N=8 EP=6 IP=0 FDC=6
M0 ZN A3 VSS VSS N L=1.8e-07 W=5e-07 $X=625 $Y=770 $D=0
M1 VSS A2 ZN VSS N L=1.8e-07 W=5e-07 $X=1345 $Y=770 $D=0
M2 ZN A1 VSS VSS N L=1.8e-07 W=5e-07 $X=2000 $Y=770 $D=0
M3 7 A3 VDD VDD P L=1.8e-07 W=1.37e-06 $X=625 $Y=2205 $D=16
M4 8 A2 7 VDD P L=1.8e-07 W=1.37e-06 $X=1225 $Y=2205 $D=16
M5 ZN A1 8 VDD P L=1.8e-07 W=1.37e-06 $X=1825 $Y=2205 $D=16
.ENDS
***************************************
.SUBCKT ICV_130 1 2 3 4 5 6
*.CALIBRE ICV_CELL 9
** N=6 EP=6 IP=8 FDC=26
X1 5 1 2 4 6 3 DFKCNQD1BWP7T $T=1680 0 0 0 $X=1390 $Y=-235
.ENDS
***************************************
.SUBCKT ICV_131 1 2 3 4 5 6
*.CALIBRE ICV_CELL 9
** N=6 EP=6 IP=8 FDC=26
X1 5 1 2 4 6 3 DFKCNQD1BWP7T $T=3360 0 0 0 $X=3070 $Y=-235
.ENDS
***************************************
.SUBCKT CKLNQD2BWP7T TE E CP VDD Q VSS
** N=18 EP=6 IP=0 FDC=24
M0 VSS TE 15 VSS N L=1.8e-07 W=5e-07 $X=620 $Y=480 $D=0
M1 15 E VSS VSS N L=1.8e-07 W=5e-07 $X=1340 $Y=480 $D=0
M2 9 10 15 VSS N L=1.8e-07 W=5e-07 $X=2060 $Y=480 $D=0
M3 17 7 9 VSS N L=1.8e-07 W=4.2e-07 $X=2820 $Y=480 $D=0
M4 VSS 8 17 VSS N L=1.8e-07 W=4.2e-07 $X=3310 $Y=480 $D=0
M5 8 9 VSS VSS N L=1.8e-07 W=5e-07 $X=4040 $Y=480 $D=0
M6 VSS 10 7 VSS N L=1.8e-07 W=5e-07 $X=5475 $Y=1000 $D=0
M7 10 CP VSS VSS N L=1.8e-07 W=5e-07 $X=6095 $Y=845 $D=0
M8 18 CP 11 VSS N L=1.8e-07 W=7e-07 $X=7570 $Y=585 $D=0
M9 VSS 8 18 VSS N L=1.8e-07 W=7e-07 $X=8395 $Y=585 $D=0
M10 Q 11 VSS VSS N L=1.8e-07 W=5.25e-07 $X=9115 $Y=760 $D=0
M11 VSS 11 Q VSS N L=1.8e-07 W=5.25e-07 $X=9840 $Y=760 $D=0
M12 12 TE VDD VDD P L=1.8e-07 W=1.37e-06 $X=620 $Y=2205 $D=16
M13 13 E 12 VDD P L=1.8e-07 W=1.37e-06 $X=1220 $Y=2205 $D=16
M14 9 7 13 VDD P L=1.8e-07 W=5.2e-07 $X=1820 $Y=2380 $D=16
M15 14 10 9 VDD P L=1.8e-07 W=4.2e-07 $X=2540 $Y=2380 $D=16
M16 VDD 8 14 VDD P L=1.8e-07 W=4.2e-07 $X=2990 $Y=2380 $D=16
M17 8 9 VDD VDD P L=1.8e-07 W=6.85e-07 $X=3840 $Y=2380 $D=16
M18 VDD 10 7 VDD P L=1.8e-07 W=6.85e-07 $X=5260 $Y=2660 $D=16
M19 10 CP VDD VDD P L=1.8e-07 W=6.85e-07 $X=5980 $Y=2660 $D=16
M20 11 CP VDD VDD P L=1.8e-07 W=1.37e-06 $X=7570 $Y=2205 $D=16
M21 VDD 8 11 VDD P L=1.8e-07 W=1.37e-06 $X=8395 $Y=2205 $D=16
M22 Q 11 VDD VDD P L=1.8e-07 W=1.37e-06 $X=9115 $Y=2205 $D=16
M23 VDD 11 Q VDD P L=1.8e-07 W=1.37e-06 $X=9840 $Y=2205 $D=16
.ENDS
***************************************
.SUBCKT AN4D1BWP7T A1 A2 A3 A4 VDD Z VSS
** N=12 EP=7 IP=0 FDC=10
M0 10 A1 8 VSS N L=1.8e-07 W=5e-07 $X=625 $Y=345 $D=0
M1 11 A2 10 VSS N L=1.8e-07 W=5e-07 $X=1205 $Y=345 $D=0
M2 12 A3 11 VSS N L=1.8e-07 W=5e-07 $X=1785 $Y=345 $D=0
M3 VSS A4 12 VSS N L=1.8e-07 W=5e-07 $X=2365 $Y=345 $D=0
M4 Z 8 VSS VSS N L=1.8e-07 W=1e-06 $X=3105 $Y=345 $D=0
M5 8 A1 VDD VDD P L=1.8e-07 W=6.85e-07 $X=460 $Y=2205 $D=16
M6 VDD A2 8 VDD P L=1.8e-07 W=6.85e-07 $X=1185 $Y=2205 $D=16
M7 8 A3 VDD VDD P L=1.8e-07 W=6.85e-07 $X=1785 $Y=2205 $D=16
M8 VDD A4 8 VDD P L=1.8e-07 W=6.85e-07 $X=2515 $Y=2205 $D=16
M9 Z 8 VDD VDD P L=1.8e-07 W=1.37e-06 $X=3115 $Y=2205 $D=16
.ENDS
***************************************
.SUBCKT CKLNQD4BWP7T TE E CP VDD Q VSS
** N=18 EP=6 IP=0 FDC=32
M0 VSS TE 15 VSS N L=1.8e-07 W=5e-07 $X=620 $Y=480 $D=0
M1 15 E VSS VSS N L=1.8e-07 W=5e-07 $X=1340 $Y=480 $D=0
M2 9 10 15 VSS N L=1.8e-07 W=5e-07 $X=2060 $Y=480 $D=0
M3 18 7 9 VSS N L=1.8e-07 W=4.2e-07 $X=2820 $Y=480 $D=0
M4 VSS 8 18 VSS N L=1.8e-07 W=4.2e-07 $X=3310 $Y=480 $D=0
M5 8 9 VSS VSS N L=1.8e-07 W=5e-07 $X=4040 $Y=480 $D=0
M6 VSS 10 7 VSS N L=1.8e-07 W=5e-07 $X=5475 $Y=1000 $D=0
M7 10 CP VSS VSS N L=1.8e-07 W=5e-07 $X=6095 $Y=750 $D=0
M8 16 CP VSS VSS N L=1.8e-07 W=5.4e-07 $X=7420 $Y=660 $D=0
M9 11 8 16 VSS N L=1.8e-07 W=5.4e-07 $X=8140 $Y=660 $D=0
M10 16 8 11 VSS N L=1.8e-07 W=5.4e-07 $X=8940 $Y=660 $D=0
M11 VSS CP 16 VSS N L=1.8e-07 W=5.4e-07 $X=9660 $Y=660 $D=0
M12 Q 11 VSS VSS N L=1.8e-07 W=5.25e-07 $X=10480 $Y=400 $D=0
M13 VSS 11 Q VSS N L=1.8e-07 W=5.25e-07 $X=11200 $Y=400 $D=0
M14 Q 11 VSS VSS N L=1.8e-07 W=5.25e-07 $X=11920 $Y=400 $D=0
M15 VSS 11 Q VSS N L=1.8e-07 W=5.25e-07 $X=12640 $Y=400 $D=0
M16 12 TE VDD VDD P L=1.8e-07 W=1.37e-06 $X=620 $Y=2205 $D=16
M17 13 E 12 VDD P L=1.8e-07 W=1.37e-06 $X=1220 $Y=2205 $D=16
M18 9 7 13 VDD P L=1.8e-07 W=5.2e-07 $X=1820 $Y=2380 $D=16
M19 14 10 9 VDD P L=1.8e-07 W=4.2e-07 $X=2540 $Y=2380 $D=16
M20 VDD 8 14 VDD P L=1.8e-07 W=4.2e-07 $X=2990 $Y=2380 $D=16
M21 8 9 VDD VDD P L=1.8e-07 W=6.85e-07 $X=3840 $Y=2380 $D=16
M22 VDD 10 7 VDD P L=1.8e-07 W=6.85e-07 $X=5260 $Y=2660 $D=16
M23 10 CP VDD VDD P L=1.8e-07 W=6.85e-07 $X=5980 $Y=2660 $D=16
M24 11 CP VDD VDD P L=1.8e-07 W=1.095e-06 $X=7420 $Y=2120 $D=16
M25 VDD 8 11 VDD P L=1.8e-07 W=1.095e-06 $X=8140 $Y=2120 $D=16
M26 11 8 VDD VDD P L=1.8e-07 W=1.095e-06 $X=8940 $Y=2120 $D=16
M27 VDD CP 11 VDD P L=1.8e-07 W=1.095e-06 $X=9660 $Y=2120 $D=16
M28 Q 11 VDD VDD P L=1.8e-07 W=1.37e-06 $X=10480 $Y=2205 $D=16
M29 VDD 11 Q VDD P L=1.8e-07 W=1.37e-06 $X=11200 $Y=2205 $D=16
M30 Q 11 VDD VDD P L=1.8e-07 W=1.37e-06 $X=11920 $Y=2205 $D=16
M31 VDD 11 Q VDD P L=1.8e-07 W=1.37e-06 $X=12640 $Y=2205 $D=16
.ENDS
***************************************
.SUBCKT AOI221D1BWP7T C B1 B2 A2 A1 VDD ZN VSS
** N=12 EP=8 IP=0 FDC=10
M0 ZN C VSS VSS N L=1.8e-07 W=1e-06 $X=625 $Y=345 $D=0
M1 11 B1 ZN VSS N L=1.8e-07 W=1e-06 $X=1345 $Y=345 $D=0
M2 VSS B2 11 VSS N L=1.8e-07 W=1e-06 $X=2065 $Y=345 $D=0
M3 12 A2 VSS VSS N L=1.8e-07 W=1e-06 $X=3520 $Y=345 $D=0
M4 ZN A1 12 VSS N L=1.8e-07 W=1e-06 $X=4240 $Y=345 $D=0
M5 9 C VDD VDD P L=1.8e-07 W=1.37e-06 $X=625 $Y=2205 $D=16
M6 10 B1 9 VDD P L=1.8e-07 W=1.37e-06 $X=1345 $Y=2205 $D=16
M7 9 B2 10 VDD P L=1.8e-07 W=1.37e-06 $X=2065 $Y=2205 $D=16
M8 ZN A2 10 VDD P L=1.8e-07 W=1.37e-06 $X=3520 $Y=2205 $D=16
M9 10 A1 ZN VDD P L=1.8e-07 W=1.37e-06 $X=4240 $Y=2205 $D=16
.ENDS
***************************************
.SUBCKT AOI211D1BWP7T C B A2 A1 VDD ZN VSS
** N=10 EP=7 IP=0 FDC=8
M0 ZN C VSS VSS N L=1.8e-07 W=1e-06 $X=620 $Y=345 $D=0
M1 VSS B ZN VSS N L=1.8e-07 W=1e-06 $X=1340 $Y=345 $D=0
M2 10 A2 VSS VSS N L=1.8e-07 W=1e-06 $X=2060 $Y=345 $D=0
M3 ZN A1 10 VSS N L=1.8e-07 W=1e-06 $X=2560 $Y=345 $D=0
M4 8 C VDD VDD P L=1.8e-07 W=1.37e-06 $X=620 $Y=2205 $D=16
M5 9 B 8 VDD P L=1.8e-07 W=1.37e-06 $X=1120 $Y=2205 $D=16
M6 ZN A2 9 VDD P L=1.8e-07 W=1.37e-06 $X=1840 $Y=2205 $D=16
M7 9 A1 ZN VDD P L=1.8e-07 W=1.37e-06 $X=2560 $Y=2205 $D=16
.ENDS
***************************************
.SUBCKT CKBD6BWP7T I VDD Z VSS
** N=5 EP=4 IP=0 FDC=17
M0 5 I VSS VSS N L=1.8e-07 W=7.2e-07 $X=1340 $Y=540 $D=0
M1 VSS I 5 VSS N L=1.8e-07 W=7.2e-07 $X=2060 $Y=540 $D=0
M2 Z 5 VSS VSS N L=1.8e-07 W=6.45e-07 $X=3500 $Y=540 $D=0
M3 VSS 5 Z VSS N L=1.8e-07 W=6.45e-07 $X=4230 $Y=540 $D=0
M4 Z 5 VSS VSS N L=1.8e-07 W=6.45e-07 $X=4950 $Y=540 $D=0
M5 VSS 5 Z VSS N L=1.8e-07 W=6.45e-07 $X=5675 $Y=540 $D=0
M6 Z 5 VSS VSS N L=1.8e-07 W=6.45e-07 $X=6395 $Y=540 $D=0
M7 VDD I 5 VDD P L=1.8e-07 W=1.37e-06 $X=620 $Y=2205 $D=16
M8 5 I VDD VDD P L=1.8e-07 W=1.37e-06 $X=1340 $Y=2205 $D=16
M9 VDD I 5 VDD P L=1.8e-07 W=1.37e-06 $X=2060 $Y=2205 $D=16
M10 Z 5 VDD VDD P L=1.8e-07 W=1.37e-06 $X=2780 $Y=2205 $D=16
M11 VDD 5 Z VDD P L=1.8e-07 W=1.37e-06 $X=3500 $Y=2205 $D=16
M12 Z 5 VDD VDD P L=1.8e-07 W=1.37e-06 $X=4225 $Y=2205 $D=16
M13 VDD 5 Z VDD P L=1.8e-07 W=1.37e-06 $X=4950 $Y=2205 $D=16
M14 Z 5 VDD VDD P L=1.8e-07 W=1.37e-06 $X=5670 $Y=2205 $D=16
M15 VDD 5 Z VDD P L=1.8e-07 W=1.37e-06 $X=6395 $Y=2205 $D=16
D16 VSS I DN AREA=2.037e-13 PJ=1.81e-06 $X=140 $Y=815 $D=26
.ENDS
***************************************
.SUBCKT OAI31D0BWP7T A1 A2 A3 B VDD ZN VSS
** N=10 EP=7 IP=0 FDC=8
M0 10 A1 ZN VSS N L=1.8e-07 W=5e-07 $X=620 $Y=845 $D=0
M1 ZN A2 10 VSS N L=1.8e-07 W=5e-07 $X=1220 $Y=845 $D=0
M2 10 A3 ZN VSS N L=1.8e-07 W=5e-07 $X=1945 $Y=845 $D=0
M3 VSS B 10 VSS N L=1.8e-07 W=5e-07 $X=2560 $Y=845 $D=0
M4 8 A1 VDD VDD P L=1.8e-07 W=6.85e-07 $X=620 $Y=2755 $D=16
M5 9 A2 8 VDD P L=1.8e-07 W=6.85e-07 $X=1210 $Y=2755 $D=16
M6 ZN A3 9 VDD P L=1.8e-07 W=6.85e-07 $X=1800 $Y=2755 $D=16
M7 VDD B ZN VDD P L=1.8e-07 W=6.85e-07 $X=2560 $Y=2755 $D=16
.ENDS
***************************************
.SUBCKT NR2XD1BWP7T A2 A1 VDD ZN VSS
** N=6 EP=5 IP=0 FDC=6
M0 ZN A2 VSS VSS N L=1.8e-07 W=1e-06 $X=1600 $Y=345 $D=0
M1 VSS A1 ZN VSS N L=1.8e-07 W=1e-06 $X=2320 $Y=345 $D=0
M2 VDD A2 6 VDD P L=1.8e-07 W=1.37e-06 $X=880 $Y=2205 $D=16
M3 6 A2 VDD VDD P L=1.8e-07 W=1.37e-06 $X=1600 $Y=2205 $D=16
M4 ZN A1 6 VDD P L=1.8e-07 W=1.37e-06 $X=2320 $Y=2205 $D=16
M5 6 A1 ZN VDD P L=1.8e-07 W=1.37e-06 $X=3040 $Y=2205 $D=16
.ENDS
***************************************
.SUBCKT ICV_132 1 2 3 4 5
*.CALIBRE ICV_CELL 9
** N=5 EP=5 IP=7 FDC=6
X1 3 5 2 4 1 INR2D1BWP7T $T=0 0 0 0 $X=-290 $Y=-235
.ENDS
***************************************
.SUBCKT AOI32D1BWP7T A3 A2 A1 B1 B2 ZN VDD VSS
** N=13 EP=8 IP=0 FDC=10
M0 11 A3 VSS VSS N L=1.8e-07 W=1e-06 $X=680 $Y=345 $D=0
M1 12 A2 11 VSS N L=1.8e-07 W=1e-06 $X=1285 $Y=345 $D=0
M2 ZN A1 12 VSS N L=1.8e-07 W=1e-06 $X=1890 $Y=345 $D=0
M3 13 B1 ZN VSS N L=1.8e-07 W=1e-06 $X=2975 $Y=345 $D=0
M4 VSS B2 13 VSS N L=1.8e-07 W=1e-06 $X=3575 $Y=345 $D=0
M5 9 A3 ZN VDD P L=1.8e-07 W=1.37e-06 $X=680 $Y=2205 $D=16
M6 ZN A2 9 VDD P L=1.8e-07 W=1.37e-06 $X=1400 $Y=2205 $D=16
M7 9 A1 ZN VDD P L=1.8e-07 W=1.37e-06 $X=2135 $Y=2205 $D=16
M8 VDD B1 9 VDD P L=1.8e-07 W=1.37e-06 $X=2855 $Y=2205 $D=16
M9 9 B2 VDD VDD P L=1.8e-07 W=1.37e-06 $X=3575 $Y=2205 $D=16
.ENDS
***************************************
.SUBCKT OR2D2BWP7T A1 A2 VDD Z VSS
** N=7 EP=5 IP=0 FDC=8
M0 6 A1 VSS VSS N L=1.8e-07 W=5e-07 $X=660 $Y=345 $D=0
M1 VSS A2 6 VSS N L=1.8e-07 W=5e-07 $X=1380 $Y=345 $D=0
M2 Z 6 VSS VSS N L=1.8e-07 W=1e-06 $X=2100 $Y=345 $D=0
M3 VSS 6 Z VSS N L=1.8e-07 W=1e-06 $X=2820 $Y=345 $D=0
M4 7 A1 6 VDD P L=1.8e-07 W=1.37e-06 $X=620 $Y=2205 $D=16
M5 VDD A2 7 VDD P L=1.8e-07 W=1.37e-06 $X=1380 $Y=2205 $D=16
M6 Z 6 VDD VDD P L=1.8e-07 W=1.37e-06 $X=2200 $Y=2205 $D=16
M7 VDD 6 Z VDD P L=1.8e-07 W=1.37e-06 $X=2920 $Y=2205 $D=16
.ENDS
***************************************
.SUBCKT ND3D2BWP7T A3 A2 A1 VDD ZN VSS
** N=10 EP=6 IP=0 FDC=12
M0 7 A3 VSS VSS N L=1.8e-07 W=1e-06 $X=700 $Y=345 $D=0
M1 8 A2 7 VSS N L=1.8e-07 W=1e-06 $X=1340 $Y=345 $D=0
M2 ZN A1 8 VSS N L=1.8e-07 W=1e-06 $X=1980 $Y=345 $D=0
M3 9 A1 ZN VSS N L=1.8e-07 W=1e-06 $X=2780 $Y=345 $D=0
M4 10 A2 9 VSS N L=1.8e-07 W=1e-06 $X=3500 $Y=345 $D=0
M5 VSS A3 10 VSS N L=1.8e-07 W=1e-06 $X=4220 $Y=345 $D=0
M6 ZN A3 VDD VDD P L=1.8e-07 W=1.37e-06 $X=620 $Y=2205 $D=16
M7 VDD A2 ZN VDD P L=1.8e-07 W=1.37e-06 $X=1340 $Y=2205 $D=16
M8 ZN A1 VDD VDD P L=1.8e-07 W=1.37e-06 $X=2060 $Y=2205 $D=16
M9 VDD A1 ZN VDD P L=1.8e-07 W=1.37e-06 $X=2780 $Y=2205 $D=16
M10 ZN A2 VDD VDD P L=1.8e-07 W=1.37e-06 $X=3500 $Y=2205 $D=16
M11 VDD A3 ZN VDD P L=1.8e-07 W=1.37e-06 $X=4220 $Y=2205 $D=16
.ENDS
***************************************
.SUBCKT ICV_133
** N=2 EP=0 IP=4 FDC=0
.ENDS
***************************************
.SUBCKT IINR4D0BWP7T A1 B1 B2 A2 VDD ZN VSS
** N=14 EP=7 IP=0 FDC=12
M0 VSS A1 8 VSS N L=1.8e-07 W=4.2e-07 $X=620 $Y=435 $D=0
M1 ZN 8 VSS VSS N L=1.8e-07 W=5e-07 $X=1340 $Y=435 $D=0
M2 VSS 9 ZN VSS N L=1.8e-07 W=5e-07 $X=2060 $Y=435 $D=0
M3 ZN B1 VSS VSS N L=1.8e-07 W=5e-07 $X=2785 $Y=435 $D=0
M4 VSS B2 ZN VSS N L=1.8e-07 W=5e-07 $X=3505 $Y=435 $D=0
M5 9 A2 VSS VSS N L=1.8e-07 W=4.2e-07 $X=4230 $Y=435 $D=0
M6 8 A1 VDD VDD P L=1.8e-07 W=4.2e-07 $X=465 $Y=2320 $D=16
M7 10 8 ZN VDD P L=1.8e-07 W=1.37e-06 $X=1725 $Y=2205 $D=16
M8 11 9 10 VDD P L=1.8e-07 W=1.37e-06 $X=2295 $Y=2205 $D=16
M9 12 B1 11 VDD P L=1.8e-07 W=1.37e-06 $X=2865 $Y=2205 $D=16
M10 VDD B2 12 VDD P L=1.8e-07 W=1.37e-06 $X=3435 $Y=2205 $D=16
M11 9 A2 VDD VDD P L=1.8e-07 W=4.2e-07 $X=4235 $Y=2900 $D=16
.ENDS
***************************************
.SUBCKT BUFFD2BWP7T I VDD Z VSS
** N=5 EP=4 IP=0 FDC=6
M0 VSS I 5 VSS N L=1.8e-07 W=1e-06 $X=680 $Y=345 $D=0
M1 Z 5 VSS VSS N L=1.8e-07 W=1e-06 $X=1590 $Y=345 $D=0
M2 VSS 5 Z VSS N L=1.8e-07 W=1e-06 $X=2430 $Y=345 $D=0
M3 VDD I 5 VDD P L=1.8e-07 W=1.37e-06 $X=680 $Y=2205 $D=16
M4 Z 5 VDD VDD P L=1.8e-07 W=1.37e-06 $X=1590 $Y=2205 $D=16
M5 VDD 5 Z VDD P L=1.8e-07 W=1.37e-06 $X=2430 $Y=2205 $D=16
.ENDS
***************************************
.SUBCKT DFXQD1BWP7T DA SA DB CP VDD Q VSS
** N=22 EP=7 IP=0 FDC=32
M0 VSS SA 8 VSS N L=1.8e-07 W=5e-07 $X=620 $Y=515 $D=0
M1 20 DA VSS VSS N L=1.8e-07 W=5.25e-07 $X=1390 $Y=775 $D=0
M2 16 SA 20 VSS N L=1.8e-07 W=5.25e-07 $X=1820 $Y=775 $D=0
M3 21 8 16 VSS N L=1.8e-07 W=1e-06 $X=2590 $Y=345 $D=0
M4 VSS DB 21 VSS N L=1.8e-07 W=1e-06 $X=3150 $Y=345 $D=0
M5 VSS CP 12 VSS N L=1.8e-07 W=5e-07 $X=4625 $Y=980 $D=0
M6 11 12 VSS VSS N L=1.8e-07 W=5e-07 $X=5315 $Y=810 $D=0
M7 10 12 16 VSS N L=1.8e-07 W=9.1e-07 $X=6735 $Y=405 $D=0
M8 22 11 10 VSS N L=1.8e-07 W=4.2e-07 $X=7455 $Y=895 $D=0
M9 VSS 9 22 VSS N L=1.8e-07 W=4.2e-07 $X=7935 $Y=895 $D=0
M10 9 10 VSS VSS N L=1.8e-07 W=5.4e-07 $X=8765 $Y=775 $D=0
M11 14 11 9 VSS N L=1.8e-07 W=9.1e-07 $X=9485 $Y=405 $D=0
M12 19 12 14 VSS N L=1.8e-07 W=4.2e-07 $X=10205 $Y=895 $D=0
M13 VSS 13 19 VSS N L=1.8e-07 W=4.2e-07 $X=10925 $Y=895 $D=0
M14 13 14 VSS VSS N L=1.8e-07 W=1e-06 $X=11735 $Y=345 $D=0
M15 Q 13 VSS VSS N L=1.8e-07 W=1e-06 $X=13200 $Y=345 $D=0
M16 VDD SA 8 VDD P L=1.8e-07 W=6.85e-07 $X=620 $Y=2655 $D=16
M17 15 DA VDD VDD P L=1.8e-07 W=9.4e-07 $X=1390 $Y=2205 $D=16
M18 16 8 15 VDD P L=1.8e-07 W=9.4e-07 $X=1830 $Y=2205 $D=16
M19 17 SA 16 VDD P L=1.8e-07 W=1.095e-06 $X=2550 $Y=2420 $D=16
M20 VDD DB 17 VDD P L=1.8e-07 W=1.23e-06 $X=3150 $Y=2345 $D=16
M21 VDD CP 12 VDD P L=1.8e-07 W=6.85e-07 $X=4625 $Y=2345 $D=16
M22 11 12 VDD VDD P L=1.8e-07 W=6.85e-07 $X=5315 $Y=2345 $D=16
M23 10 11 16 VDD P L=1.8e-07 W=9.2e-07 $X=6735 $Y=2205 $D=16
M24 18 12 10 VDD P L=1.8e-07 W=4.2e-07 $X=7455 $Y=2535 $D=16
M25 VDD 9 18 VDD P L=1.8e-07 W=4.2e-07 $X=7935 $Y=2535 $D=16
M26 9 10 VDD VDD P L=1.8e-07 W=9.6e-07 $X=8765 $Y=2175 $D=16
M27 14 12 9 VDD P L=1.8e-07 W=1.34e-06 $X=9485 $Y=2175 $D=16
M28 19 11 14 VDD P L=1.8e-07 W=4.2e-07 $X=10205 $Y=2470 $D=16
M29 VDD 13 19 VDD P L=1.8e-07 W=4.2e-07 $X=10965 $Y=2205 $D=16
M30 13 14 VDD VDD P L=1.8e-07 W=1.37e-06 $X=11735 $Y=2205 $D=16
M31 Q 13 VDD VDD P L=1.8e-07 W=1.37e-06 $X=13200 $Y=2205 $D=16
.ENDS
***************************************
.SUBCKT DFSNQD1BWP7T CP D SDN VDD Q VSS
** N=21 EP=6 IP=0 FDC=28
M0 VSS CP 10 VSS N L=1.8e-07 W=5e-07 $X=640 $Y=840 $D=0
M1 7 10 VSS VSS N L=1.8e-07 W=5e-07 $X=1240 $Y=840 $D=0
M2 18 10 VSS VSS N L=1.8e-07 W=9.4e-07 $X=2680 $Y=405 $D=0
M3 9 D 18 VSS N L=1.8e-07 W=9.4e-07 $X=3135 $Y=405 $D=0
M4 19 7 9 VSS N L=1.8e-07 W=4.2e-07 $X=3990 $Y=895 $D=0
M5 VSS 8 19 VSS N L=1.8e-07 W=4.2e-07 $X=4510 $Y=895 $D=0
M6 20 SDN VSS VSS N L=1.8e-07 W=5.4e-07 $X=5310 $Y=775 $D=0
M7 8 9 20 VSS N L=1.8e-07 W=5.4e-07 $X=5860 $Y=775 $D=0
M8 12 7 8 VSS N L=1.8e-07 W=9.1e-07 $X=6610 $Y=405 $D=0
M9 15 10 12 VSS N L=1.8e-07 W=4.2e-07 $X=7375 $Y=895 $D=0
M10 21 SDN 15 VSS N L=1.8e-07 W=5e-07 $X=8910 $Y=845 $D=0
M11 VSS 11 21 VSS N L=1.8e-07 W=5e-07 $X=9470 $Y=845 $D=0
M12 11 12 VSS VSS N L=1.8e-07 W=1e-06 $X=10350 $Y=345 $D=0
M13 VSS 11 Q VSS N L=1.8e-07 W=1e-06 $X=12080 $Y=345 $D=0
M14 VDD CP 10 VDD P L=1.8e-07 W=6.85e-07 $X=620 $Y=2345 $D=16
M15 7 10 VDD VDD P L=1.8e-07 W=6.85e-07 $X=1240 $Y=2345 $D=16
M16 13 7 VDD VDD P L=1.8e-07 W=9.2e-07 $X=2705 $Y=2205 $D=16
M17 9 D 13 VDD P L=1.8e-07 W=9.2e-07 $X=3205 $Y=2205 $D=16
M18 14 10 9 VDD P L=1.8e-07 W=4.2e-07 $X=3925 $Y=2315 $D=16
M19 VDD 8 14 VDD P L=1.8e-07 W=4.2e-07 $X=4405 $Y=2315 $D=16
M20 8 SDN VDD VDD P L=1.8e-07 W=4.2e-07 $X=5180 $Y=2175 $D=16
M21 VDD 9 8 VDD P L=1.8e-07 W=9.7e-07 $X=5900 $Y=2175 $D=16
M22 12 10 8 VDD P L=1.8e-07 W=1.34e-06 $X=7200 $Y=2175 $D=16
M23 15 7 12 VDD P L=1.8e-07 W=4.2e-07 $X=7920 $Y=2205 $D=16
M24 VDD SDN 15 VDD P L=1.8e-07 W=6.85e-07 $X=8640 $Y=2205 $D=16
M25 VDD 11 15 VDD P L=1.8e-07 W=6.85e-07 $X=9900 $Y=2205 $D=16
M26 11 12 VDD VDD P L=1.8e-07 W=1.37e-06 $X=10660 $Y=2205 $D=16
M27 VDD 11 Q VDD P L=1.8e-07 W=1.37e-06 $X=12080 $Y=2205 $D=16
.ENDS
***************************************
.SUBCKT DEL0BWP7T I VDD Z VSS
** N=7 EP=4 IP=0 FDC=8
M0 VSS I 5 VSS N L=1.8e-07 W=5e-07 $X=620 $Y=345 $D=0
M1 6 5 VSS VSS N L=2.8e-07 W=6.7e-07 $X=1340 $Y=345 $D=0
M2 VSS 6 7 VSS N L=2.8e-07 W=7e-07 $X=2860 $Y=345 $D=0
M3 Z 7 VSS VSS N L=1.8e-07 W=1e-06 $X=3680 $Y=345 $D=0
M4 VDD I 5 VDD P L=1.8e-07 W=6.85e-07 $X=620 $Y=2745 $D=16
M5 6 5 VDD VDD P L=2.8e-07 W=7.9e-07 $X=1340 $Y=2640 $D=16
M6 VDD 6 7 VDD P L=2.8e-07 W=9e-07 $X=2860 $Y=2675 $D=16
M7 Z 7 VDD VDD P L=1.8e-07 W=1.37e-06 $X=3680 $Y=2205 $D=16
.ENDS
***************************************
.SUBCKT ICV_134
** N=2 EP=0 IP=4 FDC=0
.ENDS
***************************************
.SUBCKT TIEHBWP7T VDD Z VSS
** N=4 EP=3 IP=0 FDC=2
M0 VSS 4 4 VSS N L=1.8e-07 W=1e-06 $X=760 $Y=345 $D=0
M1 Z 4 VDD VDD P L=1.8e-07 W=1.37e-06 $X=760 $Y=2205 $D=16
.ENDS
***************************************
.SUBCKT ICV_135
** N=2 EP=0 IP=4 FDC=0
.ENDS
***************************************
.SUBCKT ICV_136
** N=2 EP=0 IP=4 FDC=0
.ENDS
***************************************
.SUBCKT ICV_137
** N=2 EP=0 IP=4 FDC=0
.ENDS
***************************************
.SUBCKT ICV_138
** N=2 EP=0 IP=4 FDC=0
.ENDS
***************************************
.SUBCKT ICV_139
** N=2 EP=0 IP=4 FDC=0
.ENDS
***************************************
.SUBCKT ICV_140
** N=2 EP=0 IP=4 FDC=0
.ENDS
***************************************
.SUBCKT prbs_ber_pad_top cfg_sclk cfg_cs_n done clk cfg_re_dbg inject_error_enable_dbg checker_in 8 checker_in_final bit_error prbs_out mode_select_dbg busy 14 rst_n ext_serial_in cfg_mosi cfg_miso cfg_we_dbg input_select_dbg
** N=2220 EP=20 IP=15448 FDC=25372
M0 30 21 814 14 N L=1.8e-07 W=1e-06 $X=104220 $Y=205295 $D=0
M1 814 22 30 14 N L=1.8e-07 W=1e-06 $X=104940 $Y=205295 $D=0
M2 816 23 814 14 N L=1.8e-07 W=1e-06 $X=105660 $Y=205295 $D=0
M3 2192 24 14 14 N L=1.8e-07 W=5e-07 $X=105905 $Y=190115 $D=0
M4 814 25 816 14 N L=1.8e-07 W=1e-06 $X=106380 $Y=205295 $D=0
M5 153 26 2192 14 N L=1.8e-07 W=5e-07 $X=106515 $Y=189725 $D=0
M6 2192 27 153 14 N L=1.8e-07 W=5e-07 $X=107235 $Y=189725 $D=0
M7 14 28 816 14 N L=1.8e-07 W=1e-06 $X=107680 $Y=205295 $D=0
M8 14 29 2192 14 N L=1.8e-07 W=5e-07 $X=107835 $Y=189980 $D=0
M9 155 30 14 14 N L=1.8e-07 W=1e-06 $X=108400 $Y=205295 $D=0
M10 158 32 14 14 N L=1.8e-07 W=1e-06 $X=111030 $Y=254025 $D=0
M11 14 31 158 14 N L=1.8e-07 W=1e-06 $X=111750 $Y=254025 $D=0
M12 158 33 14 14 N L=1.8e-07 W=1e-06 $X=112560 $Y=254025 $D=0
M13 14 34 158 14 N L=1.8e-07 W=1e-06 $X=113280 $Y=254025 $D=0
M14 2193 35 14 14 N L=1.8e-07 W=1e-06 $X=119900 $Y=189615 $D=0
M15 164 36 2193 14 N L=1.8e-07 W=1e-06 $X=120625 $Y=189615 $D=0
M16 14 37 164 14 N L=1.8e-07 W=1e-06 $X=121430 $Y=189615 $D=0
M17 37 38 14 14 N L=1.8e-07 W=1e-06 $X=122240 $Y=189615 $D=0
M18 14 39 37 14 N L=1.8e-07 W=1e-06 $X=122960 $Y=189615 $D=0
M19 897 40 14 14 N L=1.8e-07 W=1e-06 $X=124180 $Y=181775 $D=0
M20 166 41 897 14 N L=1.8e-07 W=1e-06 $X=124900 $Y=181775 $D=0
M21 897 42 166 14 N L=1.8e-07 W=1e-06 $X=125620 $Y=181775 $D=0
M22 14 cfg_sclk 43 14 N L=1.8e-07 W=5e-07 $X=133340 $Y=127225 $D=0
M23 45 43 14 14 N L=7e-07 W=8.3e-07 $X=134060 $Y=126895 $D=0
M24 14 44 168 14 N L=1.8e-07 W=1e-06 $X=134460 $Y=166095 $D=0
M25 168 44 14 14 N L=1.8e-07 W=1e-06 $X=135180 $Y=166095 $D=0
M26 14 44 168 14 N L=1.8e-07 W=4.65e-07 $X=135900 $Y=166095 $D=0
M27 14 45 46 14 N L=7e-07 W=6e-07 $X=136240 $Y=127135 $D=0
M28 169 46 14 14 N L=1.8e-07 W=1e-06 $X=137480 $Y=126895 $D=0
M29 14 cfg_cs_n 47 14 N L=1.8e-07 W=1e-06 $X=161905 $Y=87695 $D=0
M30 170 47 14 14 N L=1.8e-07 W=5.2e-07 $X=162625 $Y=88175 $D=0
M31 14 48 62 14 N L=1.8e-07 W=5e-07 $X=214540 $Y=221325 $D=0
M32 14 49 48 14 N L=1.8e-07 W=4.8e-07 $X=215805 $Y=221005 $D=0
M33 171 48 14 14 N L=1.8e-07 W=4.2e-07 $X=216605 $Y=221005 $D=0
M34 49 53 171 14 N L=1.8e-07 W=4.2e-07 $X=217325 $Y=221005 $D=0
M35 52 50 49 14 N L=1.8e-07 W=9.1e-07 $X=218045 $Y=221005 $D=0
M36 14 51 52 14 N L=1.8e-07 W=5.4e-07 $X=218765 $Y=221005 $D=0
M37 2194 52 14 14 N L=1.8e-07 W=4.2e-07 $X=219565 $Y=221005 $D=0
M38 51 50 2194 14 N L=1.8e-07 W=4.2e-07 $X=219995 $Y=221005 $D=0
M39 173 53 51 14 N L=1.8e-07 W=5e-07 $X=220715 $Y=221005 $D=0
M40 14 53 50 14 N L=1.8e-07 W=9e-07 $X=222135 $Y=220980 $D=0
M41 174 54 14 14 N L=1.8e-07 W=5e-07 $X=222380 $Y=159945 $D=0
M42 53 55 14 14 N L=1.8e-07 W=5e-07 $X=222805 $Y=220840 $D=0
M43 14 56 174 14 N L=1.8e-07 W=5e-07 $X=223100 $Y=159945 $D=0
M44 174 57 14 14 N L=1.8e-07 W=5e-07 $X=223900 $Y=159945 $D=0
M45 2195 58 14 14 N L=1.8e-07 W=8.55e-07 $X=224180 $Y=221120 $D=0
M46 173 60 2195 14 N L=1.8e-07 W=8.55e-07 $X=224610 $Y=221120 $D=0
M47 14 59 174 14 N L=1.8e-07 W=5e-07 $X=224720 $Y=159945 $D=0
M48 2196 63 173 14 N L=1.8e-07 W=4.2e-07 $X=225370 $Y=221120 $D=0
M49 59 61 14 14 N L=1.8e-07 W=4.2e-07 $X=225440 $Y=160025 $D=0
M50 14 62 2196 14 N L=1.8e-07 W=4.2e-07 $X=225800 $Y=221120 $D=0
M51 60 63 14 14 N L=1.8e-07 W=5e-07 $X=226560 $Y=221305 $D=0
M52 1418 65 14 14 N L=1.8e-07 W=1e-06 $X=230220 $Y=159945 $D=0
M53 14 65 1418 14 N L=1.8e-07 W=1e-06 $X=230940 $Y=159945 $D=0
M54 180 64 14 14 N L=1.8e-07 W=4.2e-07 $X=231550 $Y=213555 $D=0
M55 1418 65 14 14 N L=1.8e-07 W=1e-06 $X=231660 $Y=159945 $D=0
M56 44 66 1418 14 N L=1.8e-07 W=1e-06 $X=232380 $Y=159945 $D=0
M57 1418 66 44 14 N L=1.8e-07 W=1e-06 $X=233100 $Y=159945 $D=0
M58 44 66 1418 14 N L=1.8e-07 W=1e-06 $X=233820 $Y=159945 $D=0
M59 14 67 78 14 N L=1.8e-07 W=5e-07 $X=242560 $Y=105560 $D=0
M60 68 78 14 14 N L=1.8e-07 W=5e-07 $X=243160 $Y=105560 $D=0
M61 2197 78 14 14 N L=1.8e-07 W=9.4e-07 $X=244600 $Y=105125 $D=0
M62 75 69 2197 14 N L=1.8e-07 W=9.4e-07 $X=245055 $Y=105125 $D=0
M63 14 70 72 14 N L=1.8e-07 W=5e-07 $X=245900 $Y=378120 $D=0
M64 2198 68 75 14 N L=1.8e-07 W=4.2e-07 $X=245910 $Y=105615 $D=0
M65 14 71 2198 14 N L=1.8e-07 W=4.2e-07 $X=246430 $Y=105615 $D=0
M66 2199 72 14 14 N L=1.8e-07 W=1e-06 $X=246700 $Y=377775 $D=0
M67 2200 73 14 14 N L=1.8e-07 W=5.4e-07 $X=247230 $Y=105495 $D=0
M68 2201 74 2199 14 N L=1.8e-07 W=1e-06 $X=247420 $Y=377775 $D=0
M69 71 75 2200 14 N L=1.8e-07 W=5.4e-07 $X=247780 $Y=105495 $D=0
M70 2202 76 2201 14 N L=1.8e-07 W=1e-06 $X=248140 $Y=377775 $D=0
M71 81 68 71 14 N L=1.8e-07 W=9.1e-07 $X=248530 $Y=105125 $D=0
M72 183 77 2202 14 N L=1.8e-07 W=1e-06 $X=248860 $Y=377775 $D=0
M73 82 78 81 14 N L=1.8e-07 W=4.2e-07 $X=249295 $Y=105615 $D=0
M74 2203 79 14 14 N L=1.8e-07 W=1e-06 $X=249400 $Y=268015 $D=0
M75 100 done 2203 14 N L=1.8e-07 W=1e-06 $X=250120 $Y=268015 $D=0
M76 2204 73 82 14 N L=1.8e-07 W=5e-07 $X=250830 $Y=105565 $D=0
M77 2205 done 100 14 N L=1.8e-07 W=1e-06 $X=250960 $Y=268015 $D=0
M78 14 80 2204 14 N L=1.8e-07 W=5e-07 $X=251390 $Y=105565 $D=0
M79 14 79 2205 14 N L=1.8e-07 W=1e-06 $X=251680 $Y=268015 $D=0
M80 80 81 14 14 N L=1.8e-07 W=1e-06 $X=252270 $Y=105065 $D=0
M81 14 80 184 14 N L=1.8e-07 W=1e-06 $X=253840 $Y=105065 $D=0
M82 85 clk 14 14 N L=1.8e-07 W=4.55e-07 $X=253900 $Y=222860 $D=0
M83 186 82 14 14 N L=1.8e-07 W=1e-06 $X=254560 $Y=105065 $D=0
M84 14 clk 85 14 N L=1.8e-07 W=4.55e-07 $X=254620 $Y=222860 $D=0
M85 14 83 185 14 N L=1.8e-07 W=1e-06 $X=254875 $Y=220975 $D=0
M86 187 85 14 14 N L=1.8e-07 W=7.3e-07 $X=255340 $Y=222860 $D=0
M87 83 84 14 14 N L=1.8e-07 W=5e-07 $X=255675 $Y=220975 $D=0
M88 14 85 187 14 N L=1.8e-07 W=7.3e-07 $X=256070 $Y=222860 $D=0
M89 187 85 14 14 N L=1.8e-07 W=7.3e-07 $X=256790 $Y=222860 $D=0
M90 14 86 188 14 N L=1.8e-07 W=1e-06 $X=257100 $Y=268015 $D=0
M91 79 87 14 14 N L=1.8e-07 W=9.4e-07 $X=257820 $Y=268015 $D=0
M92 14 88 86 14 N L=1.8e-07 W=1e-06 $X=259455 $Y=268015 $D=0
M93 87 86 14 14 N L=1.8e-07 W=4.2e-07 $X=260055 $Y=268045 $D=0
M94 88 93 87 14 N L=1.8e-07 W=4.2e-07 $X=260775 $Y=268045 $D=0
M95 91 89 88 14 N L=1.8e-07 W=9.1e-07 $X=261495 $Y=268045 $D=0
M96 14 90 91 14 N L=1.8e-07 W=5.4e-07 $X=262215 $Y=268045 $D=0
M97 2206 91 14 14 N L=1.8e-07 W=4.2e-07 $X=263015 $Y=268045 $D=0
M98 90 89 2206 14 N L=1.8e-07 W=4.2e-07 $X=263480 $Y=268045 $D=0
M99 2207 93 90 14 N L=1.8e-07 W=9.7e-07 $X=264455 $Y=268045 $D=0
M100 2208 done 2207 14 N L=1.8e-07 W=9.7e-07 $X=265075 $Y=268045 $D=0
M101 14 92 2208 14 N L=1.8e-07 W=9.7e-07 $X=265695 $Y=268045 $D=0
M102 14 93 89 14 N L=1.8e-07 W=5e-07 $X=267195 $Y=268020 $D=0
M103 93 94 14 14 N L=1.8e-07 W=5e-07 $X=268000 $Y=268020 $D=0
M104 1718 95 191 14 N L=1.8e-07 W=1e-06 $X=278380 $Y=205295 $D=0
M105 14 96 1718 14 N L=1.8e-07 W=1e-06 $X=279100 $Y=205295 $D=0
M106 2209 95 14 14 N L=1.8e-07 W=1e-06 $X=280120 $Y=205295 $D=0
M107 191 97 2209 14 N L=1.8e-07 W=1e-06 $X=280720 $Y=205295 $D=0
M108 1718 97 191 14 N L=1.8e-07 W=1e-06 $X=281440 $Y=205295 $D=0
M109 194 98 14 14 N L=1.8e-07 W=5.25e-07 $X=286270 $Y=230600 $D=0
M110 14 98 194 14 N L=1.8e-07 W=5.25e-07 $X=286990 $Y=230600 $D=0
M111 14 99 200 14 N L=1.8e-07 W=5e-07 $X=329900 $Y=136425 $D=0
M112 200 99 14 14 N L=1.8e-07 W=5e-07 $X=330620 $Y=136425 $D=0
M113 14 99 200 14 N L=1.8e-07 W=5e-07 $X=331340 $Y=136425 $D=0
M114 200 99 14 14 N L=1.8e-07 W=5e-07 $X=332060 $Y=136425 $D=0
M115 196 100 14 14 N L=1.8e-07 W=1e-06 $X=332750 $Y=322895 $D=0
M116 14 101 200 14 N L=1.8e-07 W=5e-07 $X=332780 $Y=136425 $D=0
M117 14 100 196 14 N L=1.8e-07 W=1e-06 $X=333470 $Y=322895 $D=0
M118 200 101 14 14 N L=1.8e-07 W=5e-07 $X=333500 $Y=136425 $D=0
M119 14 101 200 14 N L=1.8e-07 W=5e-07 $X=334220 $Y=136425 $D=0
M120 200 101 14 14 N L=1.8e-07 W=5e-07 $X=334940 $Y=136425 $D=0
M121 2210 102 198 14 N L=1.8e-07 W=1e-06 $X=335550 $Y=150415 $D=0
M122 2211 103 2210 14 N L=1.8e-07 W=1e-06 $X=336150 $Y=150415 $D=0
M123 14 104 200 14 N L=1.8e-07 W=5e-07 $X=336320 $Y=136425 $D=0
M124 14 cfg_re_dbg 2211 14 N L=1.8e-07 W=1e-06 $X=336750 $Y=150415 $D=0
M125 200 104 14 14 N L=1.8e-07 W=5e-07 $X=337040 $Y=136425 $D=0
M126 14 104 200 14 N L=1.8e-07 W=5e-07 $X=337760 $Y=136425 $D=0
M127 200 104 14 14 N L=1.8e-07 W=5e-07 $X=338480 $Y=136425 $D=0
M128 14 106 200 14 N L=1.8e-07 W=5e-07 $X=339200 $Y=136425 $D=0
M129 200 106 14 14 N L=1.8e-07 W=5e-07 $X=339920 $Y=136425 $D=0
M130 14 105 201 14 N L=1.8e-07 W=1e-06 $X=340575 $Y=158255 $D=0
M131 14 106 200 14 N L=1.8e-07 W=5e-07 $X=340640 $Y=136425 $D=0
M132 200 106 14 14 N L=1.8e-07 W=5e-07 $X=341360 $Y=136425 $D=0
M133 105 101 14 14 N L=1.8e-07 W=5e-07 $X=341375 $Y=158755 $D=0
M134 14 107 105 14 N L=1.8e-07 W=5e-07 $X=342095 $Y=158755 $D=0
M135 105 108 14 14 N L=1.8e-07 W=5e-07 $X=342825 $Y=158755 $D=0
M136 14 109 105 14 N L=1.8e-07 W=5e-07 $X=343545 $Y=158755 $D=0
M137 14 110 checker_in_final 14 N L=1.8e-07 W=1e-06 $X=356780 $Y=244495 $D=0
M138 115 inject_error_enable_dbg 14 14 N L=1.8e-07 W=1e-06 $X=357615 $Y=244495 $D=0
M139 14 111 205 14 N L=1.8e-07 W=5e-07 $X=357900 $Y=252725 $D=0
M140 110 113 115 14 N L=1.8e-07 W=5e-07 $X=358475 $Y=244820 $D=0
M141 2212 112 14 14 N L=1.8e-07 W=5e-07 $X=359010 $Y=252725 $D=0
M142 207 checker_in 110 14 N L=1.8e-07 W=5e-07 $X=359295 $Y=244820 $D=0
M143 111 114 2212 14 N L=1.8e-07 W=5e-07 $X=359645 $Y=252725 $D=0
M144 14 115 207 14 N L=1.8e-07 W=5e-07 $X=360080 $Y=244495 $D=0
M145 2213 116 111 14 N L=1.8e-07 W=5e-07 $X=360435 $Y=252725 $D=0
M146 14 117 2213 14 N L=1.8e-07 W=5e-07 $X=360905 $Y=252725 $D=0
M147 113 checker_in 14 14 N L=1.8e-07 W=6.85e-07 $X=360960 $Y=244495 $D=0
M148 121 119 14 14 N L=1.8e-07 W=4.2e-07 $X=361660 $Y=262250 $D=0
M149 2214 118 14 14 N L=1.8e-07 W=5e-07 $X=361705 $Y=252725 $D=0
M150 111 120 2214 14 N L=1.8e-07 W=5e-07 $X=362175 $Y=252725 $D=0
M151 14 112 121 14 N L=1.8e-07 W=4.2e-07 $X=362380 $Y=262250 $D=0
M152 bit_error 122 14 14 N L=1.8e-07 W=1e-06 $X=362600 $Y=236655 $D=0
M153 211 121 14 14 N L=1.8e-07 W=5e-07 $X=363100 $Y=262250 $D=0
M154 14 122 bit_error 14 N L=1.8e-07 W=1e-06 $X=363320 $Y=236655 $D=0
M155 14 100 211 14 N L=1.8e-07 W=5e-07 $X=363820 $Y=262250 $D=0
M156 2215 123 14 14 N L=1.8e-07 W=1e-06 $X=364040 $Y=236655 $D=0
M157 122 124 2215 14 N L=1.8e-07 W=1e-06 $X=364760 $Y=236655 $D=0
M158 14 125 136 14 N L=1.8e-07 W=5e-07 $X=370800 $Y=173940 $D=0
M159 127 136 14 14 N L=1.8e-07 W=5e-07 $X=371400 $Y=173940 $D=0
M160 14 126 129 14 N L=1.8e-07 W=5e-07 $X=372460 $Y=182100 $D=0
M161 2216 136 14 14 N L=1.8e-07 W=9.4e-07 $X=372825 $Y=173935 $D=0
M162 126 128 14 14 N L=1.8e-07 W=5e-07 $X=373260 $Y=182100 $D=0
M163 133 129 2216 14 N L=1.8e-07 W=9.4e-07 $X=373295 $Y=173935 $D=0
M164 2217 130 126 14 N L=1.8e-07 W=5e-07 $X=373980 $Y=182100 $D=0
M165 2218 127 133 14 N L=1.8e-07 W=4.2e-07 $X=374150 $Y=173965 $D=0
M166 14 135 2217 14 N L=1.8e-07 W=5e-07 $X=374410 $Y=182100 $D=0
M167 14 131 2218 14 N L=1.8e-07 W=4.2e-07 $X=374645 $Y=173965 $D=0
M168 2219 132 14 14 N L=1.8e-07 W=5e-07 $X=375180 $Y=181845 $D=0
M169 131 133 14 14 N L=1.8e-07 W=5.4e-07 $X=375445 $Y=173965 $D=0
M170 126 134 2219 14 N L=1.8e-07 W=5e-07 $X=375625 $Y=181845 $D=0
M171 138 127 131 14 N L=1.8e-07 W=9.1e-07 $X=376165 $Y=173965 $D=0
M172 216 136 138 14 N L=1.8e-07 W=4.2e-07 $X=376885 $Y=173965 $D=0
M173 14 137 216 14 N L=1.8e-07 W=4.2e-07 $X=377605 $Y=173965 $D=0
M174 137 138 14 14 N L=1.8e-07 W=5e-07 $X=378460 $Y=174350 $D=0
M175 217 137 14 14 N L=1.8e-07 W=5e-07 $X=380000 $Y=174350 $D=0
M176 14 139 140 14 N L=1.8e-07 W=5e-07 $X=382540 $Y=197455 $D=0
M177 219 140 14 14 N L=1.8e-07 W=5e-07 $X=383340 $Y=197455 $D=0
M178 14 141 219 14 N L=1.8e-07 W=1e-06 $X=384100 $Y=197455 $D=0
M179 14 142 146 14 N L=1.8e-07 W=5e-07 $X=385410 $Y=197320 $D=0
M180 145 146 14 14 N L=1.8e-07 W=5e-07 $X=386010 $Y=197460 $D=0
M181 144 146 219 14 N L=1.8e-07 W=9.4e-07 $X=387455 $Y=197455 $D=0
M182 2220 145 144 14 N L=1.8e-07 W=4.2e-07 $X=388180 $Y=197485 $D=0
M183 14 143 2220 14 N L=1.8e-07 W=4.2e-07 $X=388645 $Y=197485 $D=0
M184 143 144 14 14 N L=1.8e-07 W=5.4e-07 $X=389445 $Y=197485 $D=0
M185 148 145 143 14 N L=1.8e-07 W=9.1e-07 $X=390165 $Y=197485 $D=0
M186 149 146 148 14 N L=1.8e-07 W=4.2e-07 $X=390885 $Y=197485 $D=0
M187 14 147 149 14 N L=1.8e-07 W=5e-07 $X=391605 $Y=197455 $D=0
M188 147 148 14 14 N L=1.8e-07 W=5e-07 $X=392205 $Y=197455 $D=0
M189 14 149 221 14 N L=1.8e-07 W=5e-07 $X=393840 $Y=197855 $D=0
M190 222 147 14 14 N L=1.8e-07 W=5e-07 $X=394560 $Y=197855 $D=0
M191 150 21 8 8 P L=1.8e-07 W=1.37e-06 $X=104240 $Y=203065 $D=16
M192 30 22 150 8 P L=1.8e-07 W=1.37e-06 $X=104800 $Y=203065 $D=16
M193 151 23 30 8 P L=1.8e-07 W=1.37e-06 $X=105520 $Y=203065 $D=16
M194 152 26 8 8 P L=1.8e-07 W=6.85e-07 $X=105900 $Y=187385 $D=16
M195 8 25 151 8 P L=1.8e-07 W=1.225e-06 $X=106220 $Y=203065 $D=16
M196 153 27 152 8 P L=1.8e-07 W=6.85e-07 $X=106330 $Y=187385 $D=16
M197 154 24 153 8 P L=1.8e-07 W=6.85e-07 $X=107130 $Y=187385 $D=16
M198 8 28 30 8 P L=1.8e-07 W=1.225e-06 $X=107680 $Y=203065 $D=16
M199 8 29 154 8 P L=1.8e-07 W=6.85e-07 $X=107835 $Y=187385 $D=16
M200 155 30 8 8 P L=1.8e-07 W=1.37e-06 $X=108400 $Y=203065 $D=16
M201 157 31 156 8 P L=1.8e-07 W=1.37e-06 $X=109820 $Y=255885 $D=16
M202 158 32 157 8 P L=1.8e-07 W=1.37e-06 $X=110360 $Y=255885 $D=16
M203 159 32 158 8 P L=1.8e-07 W=1.37e-06 $X=111080 $Y=255885 $D=16
M204 160 31 159 8 P L=1.8e-07 W=1.37e-06 $X=111670 $Y=255885 $D=16
M205 161 33 160 8 P L=1.8e-07 W=1.37e-06 $X=112260 $Y=255885 $D=16
M206 8 34 161 8 P L=1.8e-07 W=1.37e-06 $X=112850 $Y=255885 $D=16
M207 162 34 8 8 P L=1.8e-07 W=1.37e-06 $X=113570 $Y=255885 $D=16
M208 156 33 162 8 P L=1.8e-07 W=1.37e-06 $X=114000 $Y=255885 $D=16
M209 164 35 163 8 P L=1.8e-07 W=1.37e-06 $X=119900 $Y=187385 $D=16
M210 163 36 164 8 P L=1.8e-07 W=1.37e-06 $X=120625 $Y=187385 $D=16
M211 8 37 163 8 P L=1.8e-07 W=1.37e-06 $X=121430 $Y=187385 $D=16
M212 165 38 8 8 P L=1.8e-07 W=1.37e-06 $X=122250 $Y=187385 $D=16
M213 37 39 165 8 P L=1.8e-07 W=1.37e-06 $X=122960 $Y=187385 $D=16
M214 8 40 166 8 P L=1.8e-07 W=1.37e-06 $X=124180 $Y=179545 $D=16
M215 167 41 8 8 P L=1.8e-07 W=1.37e-06 $X=124900 $Y=179545 $D=16
M216 166 42 167 8 P L=1.8e-07 W=1.37e-06 $X=125620 $Y=179545 $D=16
M217 8 cfg_sclk 43 8 P L=1.8e-07 W=6.85e-07 $X=133340 $Y=124760 $D=16
M218 45 43 8 8 P L=7e-07 W=1.2e-06 $X=134060 $Y=124760 $D=16
M219 8 44 168 8 P L=1.8e-07 W=1.37e-06 $X=134460 $Y=163865 $D=16
M220 168 44 8 8 P L=1.8e-07 W=1.37e-06 $X=135180 $Y=163865 $D=16
M221 8 44 168 8 P L=1.8e-07 W=6.85e-07 $X=135900 $Y=164550 $D=16
M222 8 45 46 8 P L=7e-07 W=9e-07 $X=136240 $Y=124665 $D=16
M223 169 46 8 8 P L=1.8e-07 W=1.37e-06 $X=137480 $Y=124665 $D=16
M224 8 cfg_cs_n 47 8 P L=1.8e-07 W=1.37e-06 $X=161905 $Y=85465 $D=16
M225 170 47 8 8 P L=1.8e-07 W=1.06e-06 $X=162625 $Y=85465 $D=16
M226 8 48 62 8 P L=1.8e-07 W=6.85e-07 $X=214540 $Y=218955 $D=16
M227 8 49 48 8 P L=1.8e-07 W=6.85e-07 $X=215805 $Y=219430 $D=16
M228 171 48 8 8 P L=1.8e-07 W=4.2e-07 $X=216565 $Y=219695 $D=16
M229 49 50 171 8 P L=1.8e-07 W=4.2e-07 $X=217325 $Y=219430 $D=16
M230 52 53 49 8 P L=1.8e-07 W=1.34e-06 $X=218045 $Y=218805 $D=16
M231 8 51 52 8 P L=1.8e-07 W=9.6e-07 $X=218765 $Y=219185 $D=16
M232 172 52 8 8 P L=1.8e-07 W=4.2e-07 $X=219565 $Y=219195 $D=16
M233 51 53 172 8 P L=1.8e-07 W=4.2e-07 $X=220095 $Y=219195 $D=16
M234 173 50 51 8 P L=1.8e-07 W=9.2e-07 $X=220895 $Y=219195 $D=16
M235 8 53 50 8 P L=1.8e-07 W=6e-07 $X=222320 $Y=219375 $D=16
M236 175 54 174 8 P L=1.8e-07 W=1.37e-06 $X=222460 $Y=161805 $D=16
M237 53 55 8 8 P L=1.8e-07 W=6.85e-07 $X=222920 $Y=219290 $D=16
M238 176 56 175 8 P L=1.8e-07 W=1.37e-06 $X=223180 $Y=161805 $D=16
M239 177 57 176 8 P L=1.8e-07 W=1.37e-06 $X=223900 $Y=161805 $D=16
M240 178 58 8 8 P L=1.8e-07 W=1.075e-06 $X=224180 $Y=218805 $D=16
M241 173 63 178 8 P L=1.8e-07 W=1.075e-06 $X=224610 $Y=218805 $D=16
M242 8 59 177 8 P L=1.8e-07 W=1.37e-06 $X=224620 $Y=161805 $D=16
M243 179 60 173 8 P L=1.8e-07 W=4.2e-07 $X=225370 $Y=219175 $D=16
M244 59 61 8 8 P L=1.8e-07 W=4.2e-07 $X=225440 $Y=162070 $D=16
M245 8 62 179 8 P L=1.8e-07 W=4.2e-07 $X=225800 $Y=219175 $D=16
M246 60 63 8 8 P L=1.8e-07 W=6.85e-07 $X=226560 $Y=218910 $D=16
M247 44 65 8 8 P L=1.8e-07 W=1.37e-06 $X=230220 $Y=161805 $D=16
M248 8 65 44 8 P L=1.8e-07 W=1.37e-06 $X=230940 $Y=161805 $D=16
M249 180 64 8 8 P L=1.8e-07 W=1.13e-06 $X=231550 $Y=210905 $D=16
M250 44 65 8 8 P L=1.8e-07 W=1.37e-06 $X=231660 $Y=161805 $D=16
M251 8 66 44 8 P L=1.8e-07 W=1.37e-06 $X=232380 $Y=161805 $D=16
M252 44 66 8 8 P L=1.8e-07 W=1.37e-06 $X=233100 $Y=161805 $D=16
M253 8 66 44 8 P L=1.8e-07 W=1.37e-06 $X=233820 $Y=161805 $D=16
M254 8 67 78 8 P L=1.8e-07 W=6.85e-07 $X=242540 $Y=107065 $D=16
M255 68 78 8 8 P L=1.8e-07 W=6.85e-07 $X=243160 $Y=107065 $D=16
M256 181 68 8 8 P L=1.8e-07 W=9.2e-07 $X=244625 $Y=106925 $D=16
M257 75 69 181 8 P L=1.8e-07 W=9.2e-07 $X=245125 $Y=106925 $D=16
M258 182 78 75 8 P L=1.8e-07 W=4.2e-07 $X=245845 $Y=107035 $D=16
M259 8 70 72 8 P L=1.8e-07 W=6.85e-07 $X=245900 $Y=376230 $D=16
M260 8 71 182 8 P L=1.8e-07 W=4.2e-07 $X=246325 $Y=107035 $D=16
M261 183 72 8 8 P L=1.8e-07 W=1.37e-06 $X=246700 $Y=375545 $D=16
M262 71 73 8 8 P L=1.8e-07 W=4.2e-07 $X=247100 $Y=106895 $D=16
M263 8 74 183 8 P L=1.8e-07 W=1.37e-06 $X=247420 $Y=375545 $D=16
M264 8 75 71 8 P L=1.8e-07 W=9.7e-07 $X=247820 $Y=106895 $D=16
M265 183 76 8 8 P L=1.8e-07 W=1.37e-06 $X=248140 $Y=375545 $D=16
M266 8 77 183 8 P L=1.8e-07 W=1.37e-06 $X=248860 $Y=375545 $D=16
M267 81 78 71 8 P L=1.8e-07 W=1.34e-06 $X=249120 $Y=106895 $D=16
M268 100 79 8 8 P L=1.8e-07 W=1.37e-06 $X=249400 $Y=265785 $D=16
M269 82 68 81 8 P L=1.8e-07 W=4.2e-07 $X=249840 $Y=106925 $D=16
M270 8 done 100 8 P L=1.8e-07 W=1.37e-06 $X=250120 $Y=265785 $D=16
M271 8 73 82 8 P L=1.8e-07 W=6.85e-07 $X=250560 $Y=106925 $D=16
M272 100 done 8 8 P L=1.8e-07 W=1.37e-06 $X=250960 $Y=265785 $D=16
M273 8 79 100 8 P L=1.8e-07 W=1.37e-06 $X=251680 $Y=265785 $D=16
M274 8 80 82 8 P L=1.8e-07 W=6.85e-07 $X=251820 $Y=106925 $D=16
M275 80 81 8 8 P L=1.8e-07 W=1.37e-06 $X=252420 $Y=106925 $D=16
M276 85 clk 8 8 P L=1.8e-07 W=1.37e-06 $X=253180 $Y=224525 $D=16
M277 8 80 184 8 P L=1.8e-07 W=1.37e-06 $X=253840 $Y=106925 $D=16
M278 8 clk 85 8 P L=1.8e-07 W=1.37e-06 $X=253900 $Y=224525 $D=16
M279 186 82 8 8 P L=1.8e-07 W=1.37e-06 $X=254560 $Y=106925 $D=16
M280 187 85 8 8 P L=1.8e-07 W=1.37e-06 $X=254620 $Y=224525 $D=16
M281 8 83 185 8 P L=1.8e-07 W=1.37e-06 $X=254875 $Y=218745 $D=16
M282 8 85 187 8 P L=1.8e-07 W=1.37e-06 $X=255340 $Y=224525 $D=16
M283 83 84 8 8 P L=1.8e-07 W=6.85e-07 $X=255675 $Y=219430 $D=16
M284 187 85 8 8 P L=1.8e-07 W=1.37e-06 $X=256065 $Y=224525 $D=16
M285 8 85 187 8 P L=1.8e-07 W=1.37e-06 $X=256790 $Y=224525 $D=16
M286 8 86 188 8 P L=1.8e-07 W=1.37e-06 $X=257100 $Y=265785 $D=16
M287 79 87 8 8 P L=1.8e-07 W=1.37e-06 $X=257820 $Y=265785 $D=16
M288 8 88 86 8 P L=1.8e-07 W=1.37e-06 $X=259245 $Y=265785 $D=16
M289 87 86 8 8 P L=1.8e-07 W=6.85e-07 $X=260015 $Y=266470 $D=16
M290 88 89 87 8 P L=1.8e-07 W=4.2e-07 $X=260775 $Y=266470 $D=16
M291 91 93 88 8 P L=1.8e-07 W=1.34e-06 $X=261495 $Y=265845 $D=16
M292 8 90 91 8 P L=1.8e-07 W=9.6e-07 $X=262215 $Y=266225 $D=16
M293 189 91 8 8 P L=1.8e-07 W=4.2e-07 $X=263015 $Y=266235 $D=16
M294 90 93 189 8 P L=1.8e-07 W=4.2e-07 $X=263445 $Y=266235 $D=16
M295 190 89 90 8 P L=1.8e-07 W=6.5e-07 $X=264355 $Y=266535 $D=16
M296 8 done 190 8 P L=1.8e-07 W=9.5e-07 $X=265180 $Y=266235 $D=16
M297 190 92 8 8 P L=1.8e-07 W=4.2e-07 $X=265980 $Y=266625 $D=16
M298 8 93 89 8 P L=1.8e-07 W=6.85e-07 $X=267400 $Y=266330 $D=16
M299 93 94 8 8 P L=1.8e-07 W=6.85e-07 $X=268000 $Y=266330 $D=16
M300 192 95 191 8 P L=1.8e-07 W=1.37e-06 $X=278380 $Y=203065 $D=16
M301 8 96 192 8 P L=1.8e-07 W=1.37e-06 $X=279100 $Y=203065 $D=16
M302 193 95 8 8 P L=1.8e-07 W=1.37e-06 $X=279990 $Y=203065 $D=16
M303 191 97 193 8 P L=1.8e-07 W=1.37e-06 $X=280720 $Y=203065 $D=16
M304 192 97 191 8 P L=1.8e-07 W=1.37e-06 $X=281440 $Y=203065 $D=16
M305 194 98 8 8 P L=1.8e-07 W=1.37e-06 $X=286270 $Y=232365 $D=16
M306 8 98 194 8 P L=1.8e-07 W=1.37e-06 $X=286990 $Y=232365 $D=16
M307 8 99 195 8 P L=1.8e-07 W=1.37e-06 $X=329900 $Y=138285 $D=16
M308 195 99 8 8 P L=1.8e-07 W=1.37e-06 $X=330620 $Y=138285 $D=16
M309 8 99 195 8 P L=1.8e-07 W=1.37e-06 $X=331340 $Y=138285 $D=16
M310 195 99 8 8 P L=1.8e-07 W=1.37e-06 $X=332060 $Y=138285 $D=16
M311 196 100 8 8 P L=1.8e-07 W=1.37e-06 $X=332750 $Y=320665 $D=16
M312 197 101 195 8 P L=1.8e-07 W=1.37e-06 $X=332780 $Y=138285 $D=16
M313 8 100 196 8 P L=1.8e-07 W=1.37e-06 $X=333470 $Y=320665 $D=16
M314 195 101 197 8 P L=1.8e-07 W=1.37e-06 $X=333500 $Y=138285 $D=16
M315 197 101 195 8 P L=1.8e-07 W=1.37e-06 $X=334220 $Y=138285 $D=16
M316 195 101 197 8 P L=1.8e-07 W=1.37e-06 $X=334940 $Y=138285 $D=16
M317 8 102 198 8 P L=1.8e-07 W=1.37e-06 $X=335310 $Y=148185 $D=16
M318 198 103 8 8 P L=1.8e-07 W=1.37e-06 $X=336030 $Y=148185 $D=16
M319 197 104 199 8 P L=1.8e-07 W=1.37e-06 $X=336320 $Y=138285 $D=16
M320 8 cfg_re_dbg 198 8 P L=1.8e-07 W=1.37e-06 $X=336750 $Y=148185 $D=16
M321 199 104 197 8 P L=1.8e-07 W=1.37e-06 $X=337040 $Y=138285 $D=16
M322 197 104 199 8 P L=1.8e-07 W=1.37e-06 $X=337760 $Y=138285 $D=16
M323 199 104 197 8 P L=1.8e-07 W=1.37e-06 $X=338480 $Y=138285 $D=16
M324 200 106 199 8 P L=1.8e-07 W=1.37e-06 $X=339200 $Y=138285 $D=16
M325 199 106 200 8 P L=1.8e-07 W=1.37e-06 $X=339920 $Y=138285 $D=16
M326 200 106 199 8 P L=1.8e-07 W=1.37e-06 $X=340640 $Y=138285 $D=16
M327 8 105 201 8 P L=1.8e-07 W=1.37e-06 $X=340945 $Y=156025 $D=16
M328 199 106 200 8 P L=1.8e-07 W=1.37e-06 $X=341360 $Y=138285 $D=16
M329 202 101 8 8 P L=1.8e-07 W=1.37e-06 $X=341695 $Y=156025 $D=16
M330 203 107 202 8 P L=1.8e-07 W=1.37e-06 $X=342295 $Y=156025 $D=16
M331 204 108 203 8 P L=1.8e-07 W=1.37e-06 $X=342895 $Y=156025 $D=16
M332 105 109 204 8 P L=1.8e-07 W=1.37e-06 $X=343495 $Y=156025 $D=16
M333 8 110 checker_in_final 8 P L=1.8e-07 W=1.37e-06 $X=356795 $Y=242265 $D=16
M334 115 inject_error_enable_dbg 8 8 P L=1.8e-07 W=1.37e-06 $X=357585 $Y=242265 $D=16
M335 8 111 205 8 P L=1.8e-07 W=6.85e-07 $X=357900 $Y=250695 $D=16
M336 110 checker_in 115 8 P L=1.8e-07 W=6.85e-07 $X=358345 $Y=242710 $D=16
M337 207 113 110 8 P L=1.8e-07 W=6.85e-07 $X=359125 $Y=242710 $D=16
M338 8 112 206 8 P L=1.8e-07 W=6.85e-07 $X=359160 $Y=250495 $D=16
M339 206 114 8 8 P L=1.8e-07 W=6.85e-07 $X=359960 $Y=250495 $D=16
M340 8 115 207 8 P L=1.8e-07 W=6.85e-07 $X=360080 $Y=242710 $D=16
M341 209 116 206 8 P L=1.8e-07 W=6.85e-07 $X=360680 $Y=250495 $D=16
M342 113 checker_in 8 8 P L=1.8e-07 W=6.85e-07 $X=360960 $Y=242710 $D=16
M343 111 118 209 8 P L=1.8e-07 W=6.85e-07 $X=361300 $Y=250495 $D=16
M344 208 119 121 8 P L=1.8e-07 W=4.2e-07 $X=361820 $Y=264380 $D=16
M345 209 120 111 8 P L=1.8e-07 W=6.85e-07 $X=362020 $Y=250495 $D=16
M346 8 112 208 8 P L=1.8e-07 W=4.2e-07 $X=362385 $Y=264380 $D=16
M347 bit_error 122 8 8 P L=1.8e-07 W=1.37e-06 $X=362600 $Y=234425 $D=16
M348 206 117 209 8 P L=1.8e-07 W=6.85e-07 $X=362640 $Y=250235 $D=16
M349 210 121 8 8 P L=1.8e-07 W=6.85e-07 $X=363145 $Y=264380 $D=16
M350 8 122 bit_error 8 P L=1.8e-07 W=1.37e-06 $X=363320 $Y=234425 $D=16
M351 211 100 210 8 P L=1.8e-07 W=6.85e-07 $X=363715 $Y=264380 $D=16
M352 122 123 8 8 P L=1.8e-07 W=1.37e-06 $X=364040 $Y=234425 $D=16
M353 8 124 122 8 P L=1.8e-07 W=1.37e-06 $X=364760 $Y=234425 $D=16
M354 8 125 136 8 P L=1.8e-07 W=6.85e-07 $X=370780 $Y=172250 $D=16
M355 127 136 8 8 P L=1.8e-07 W=6.85e-07 $X=371400 $Y=172250 $D=16
M356 8 126 129 8 P L=1.8e-07 W=6.85e-07 $X=372460 $Y=179880 $D=16
M357 212 127 8 8 P L=1.8e-07 W=9.2e-07 $X=372865 $Y=172155 $D=16
M358 213 128 8 8 P L=1.8e-07 W=6.85e-07 $X=373180 $Y=179880 $D=16
M359 133 129 212 8 P L=1.8e-07 W=9.2e-07 $X=373365 $Y=172155 $D=16
M360 215 130 213 8 P L=1.8e-07 W=6.85e-07 $X=373900 $Y=179880 $D=16
M361 214 136 133 8 P L=1.8e-07 W=4.2e-07 $X=374145 $Y=172155 $D=16
M362 126 132 215 8 P L=1.8e-07 W=6.85e-07 $X=374620 $Y=179880 $D=16
M363 8 131 214 8 P L=1.8e-07 W=4.2e-07 $X=374645 $Y=172155 $D=16
M364 215 134 126 8 P L=1.8e-07 W=6.85e-07 $X=375340 $Y=179880 $D=16
M365 131 133 8 8 P L=1.8e-07 W=9.6e-07 $X=375445 $Y=172145 $D=16
M366 213 135 215 8 P L=1.8e-07 W=6.85e-07 $X=376060 $Y=179880 $D=16
M367 138 136 131 8 P L=1.8e-07 W=1.34e-06 $X=376165 $Y=171765 $D=16
M368 216 127 138 8 P L=1.8e-07 W=4.2e-07 $X=376885 $Y=172390 $D=16
M369 8 137 216 8 P L=1.8e-07 W=4.2e-07 $X=377645 $Y=172655 $D=16
M370 137 138 8 8 P L=1.8e-07 W=6.85e-07 $X=378460 $Y=171705 $D=16
M371 217 137 8 8 P L=1.8e-07 W=6.85e-07 $X=380000 $Y=171925 $D=16
M372 8 139 140 8 P L=1.8e-07 W=6.85e-07 $X=382540 $Y=195910 $D=16
M373 218 140 8 8 P L=1.8e-07 W=1.37e-06 $X=383340 $Y=195225 $D=16
M374 219 141 218 8 P L=1.8e-07 W=1.37e-06 $X=383800 $Y=195225 $D=16
M375 8 142 146 8 P L=1.8e-07 W=6.85e-07 $X=385355 $Y=195770 $D=16
M376 145 146 8 8 P L=1.8e-07 W=6.85e-07 $X=386010 $Y=195770 $D=16
M377 144 145 219 8 P L=1.8e-07 W=9.2e-07 $X=387455 $Y=195675 $D=16
M378 220 146 144 8 P L=1.8e-07 W=4.2e-07 $X=388215 $Y=195675 $D=16
M379 8 143 220 8 P L=1.8e-07 W=4.2e-07 $X=388645 $Y=195675 $D=16
M380 143 144 8 8 P L=1.8e-07 W=9.6e-07 $X=389445 $Y=195665 $D=16
M381 148 146 143 8 P L=1.8e-07 W=1.34e-06 $X=390165 $Y=195285 $D=16
M382 149 145 148 8 P L=1.8e-07 W=4.2e-07 $X=390885 $Y=195910 $D=16
M383 8 147 149 8 P L=1.8e-07 W=6.85e-07 $X=391645 $Y=195910 $D=16
M384 147 148 8 8 P L=1.8e-07 W=6.85e-07 $X=392415 $Y=195225 $D=16
M385 8 149 221 8 P L=1.8e-07 W=6.85e-07 $X=393840 $Y=195910 $D=16
M386 222 147 8 8 P L=1.8e-07 W=6.85e-07 $X=394560 $Y=195910 $D=16
D387 14 clk DN AREA=2.037e-13 PJ=1.81e-06 $X=252700 $Y=223135 $D=26
X1682 2070 135 1798 8 335 14 MUX2D1BWP7T $T=359520 151760 0 180 $X=354190 $Y=147550
X1683 2084 135 1806 8 553 14 MUX2D1BWP7T $T=361200 143920 0 180 $X=355870 $Y=139710
X1684 2088 135 1818 8 624 14 MUX2D1BWP7T $T=364000 167440 1 180 $X=358670 $Y=167205
X1685 2096 135 1640 8 554 14 MUX2D1BWP7T $T=362880 143920 1 0 $X=362590 $Y=139710
X1686 2104 135 580 8 467 14 MUX2D1BWP7T $T=364000 151760 0 0 $X=363710 $Y=151525
X1687 2131 135 1685 8 344 14 MUX2D1BWP7T $T=378560 143920 1 180 $X=373230 $Y=143685
X1688 2135 135 1951 8 345 14 MUX2D1BWP7T $T=380240 151760 0 180 $X=374910 $Y=147550
X1689 217 135 2053 8 355 14 MUX2D1BWP7T $T=381920 183120 1 0 $X=381630 $Y=178910
X1690 2147 135 2011 8 346 14 MUX2D1BWP7T $T=388080 167440 0 180 $X=382750 $Y=163230
X1691 222 528 2053 8 384 14 MUX2D1BWP7T $T=390320 206640 0 180 $X=384990 $Y=202430
X1692 2157 528 2056 8 349 14 MUX2D1BWP7T $T=393680 183120 1 180 $X=388350 $Y=182885
X1693 2150 135 2060 8 357 14 MUX2D1BWP7T $T=389760 167440 0 0 $X=389470 $Y=167205
X1694 2151 135 2056 8 468 14 MUX2D1BWP7T $T=390880 167440 1 0 $X=390590 $Y=163230
X1695 2160 135 2042 8 356 14 MUX2D1BWP7T $T=391440 183120 1 0 $X=391150 $Y=178910
X1696 2162 528 2042 8 367 14 MUX2D1BWP7T $T=399840 198800 1 180 $X=394510 $Y=198565
X1697 2163 528 2060 8 368 14 MUX2D1BWP7T $T=400960 183120 1 180 $X=395630 $Y=182885
X1737 909 754 8 898 14 INR2XD0BWP7T $T=130480 190960 0 0 $X=130190 $Y=190725
X1738 957 417 8 976 14 INR2XD0BWP7T $T=148400 112560 0 180 $X=145310 $Y=108350
X1739 1013 417 8 978 14 INR2XD0BWP7T $T=153440 120400 1 180 $X=150350 $Y=120165
X1740 963 417 8 1007 14 INR2XD0BWP7T $T=161840 120400 0 180 $X=158750 $Y=116190
X1741 1014 417 8 1037 14 INR2XD0BWP7T $T=159040 128240 1 0 $X=158750 $Y=124030
X1742 1067 417 8 1096 14 INR2XD0BWP7T $T=169120 120400 1 0 $X=168830 $Y=116190
X1743 1153 417 8 1114 14 INR2XD0BWP7T $T=179200 128240 0 180 $X=176110 $Y=124030
X1744 668 98 8 476 14 INR2XD0BWP7T $T=176400 214480 1 0 $X=176110 $Y=210270
X1745 586 98 8 619 14 INR2XD0BWP7T $T=177520 245840 1 0 $X=177230 $Y=241630
X1746 793 98 8 529 14 INR2XD0BWP7T $T=178640 222320 0 0 $X=178350 $Y=222085
X1747 394 98 8 564 14 INR2XD0BWP7T $T=180320 214480 1 0 $X=180030 $Y=210270
X1748 1182 417 8 1192 14 INR2XD0BWP7T $T=187040 120400 1 0 $X=186750 $Y=116190
X1749 1149 417 8 1193 14 INR2XD0BWP7T $T=187040 128240 0 0 $X=186750 $Y=128005
X1750 1230 417 8 1213 14 INR2XD0BWP7T $T=195440 120400 0 180 $X=192350 $Y=116190
X1751 584 98 8 447 14 INR2XD0BWP7T $T=193760 206640 0 0 $X=193470 $Y=206405
X1752 399 98 8 454 14 INR2XD0BWP7T $T=195440 198800 0 0 $X=195150 $Y=198565
X1753 1246 417 8 1233 14 INR2XD0BWP7T $T=201600 120400 0 180 $X=198510 $Y=116190
X1754 398 98 8 364 14 INR2XD0BWP7T $T=203280 198800 1 0 $X=202990 $Y=194590
X1755 1224 417 8 1274 14 INR2XD0BWP7T $T=204400 112560 1 0 $X=204110 $Y=108350
X1756 1225 417 8 1285 14 INR2XD0BWP7T $T=206640 120400 1 0 $X=206350 $Y=116190
X1757 593 98 8 565 14 INR2XD0BWP7T $T=208880 190960 1 0 $X=208590 $Y=186750
X1758 1287 417 8 1289 14 INR2XD0BWP7T $T=212240 128240 1 180 $X=209150 $Y=128005
X1759 1320 417 8 1340 14 INR2XD0BWP7T $T=217280 112560 0 0 $X=216990 $Y=112325
X1760 1362 417 8 1341 14 INR2XD0BWP7T $T=221200 120400 0 180 $X=218110 $Y=116190
X1761 1376 1343 8 1359 14 INR2XD0BWP7T $T=225680 245840 1 180 $X=222590 $Y=245605
X1762 1397 417 8 1373 14 INR2XD0BWP7T $T=229600 128240 1 0 $X=229310 $Y=124030
X1763 595 98 8 273 14 INR2XD0BWP7T $T=233520 206640 0 180 $X=230430 $Y=202430
X1764 1445 417 8 1456 14 INR2XD0BWP7T $T=238000 120400 1 0 $X=237710 $Y=116190
X1765 1554 417 8 1542 14 INR2XD0BWP7T $T=254800 120400 0 180 $X=251710 $Y=116190
X1766 1481 417 8 1533 14 INR2XD0BWP7T $T=254800 136080 1 0 $X=254510 $Y=131870
X1767 1558 417 8 1581 14 INR2XD0BWP7T $T=256480 112560 0 0 $X=256190 $Y=112325
X1768 419 98 8 378 14 INR2XD0BWP7T $T=276640 214480 1 180 $X=273550 $Y=214245
X1769 1638 1673 8 1669 14 INR2XD0BWP7T $T=277200 89040 0 180 $X=274110 $Y=84830
X1770 1623 417 8 1618 14 INR2XD0BWP7T $T=278880 128240 1 180 $X=275790 $Y=128005
X1771 1697 630 8 472 14 INR2XD0BWP7T $T=279440 308560 0 0 $X=279150 $Y=308325
X1772 1709 417 8 1710 14 INR2XD0BWP7T $T=281120 89040 0 0 $X=280830 $Y=88805
X1773 1731 417 8 1727 14 INR2XD0BWP7T $T=283920 112560 1 180 $X=280830 $Y=112325
X1774 1737 417 8 1687 14 INR2XD0BWP7T $T=283920 136080 0 180 $X=280830 $Y=131870
X1775 1639 417 8 1747 14 INR2XD0BWP7T $T=283360 120400 0 0 $X=283070 $Y=120165
X1776 1816 417 8 1787 14 INR2XD0BWP7T $T=295120 120400 1 180 $X=292030 $Y=120165
X1777 1825 417 8 1812 14 INR2XD0BWP7T $T=300720 120400 0 180 $X=297630 $Y=116190
X1778 732 100 8 547 14 INR2XD0BWP7T $T=304080 277200 1 180 $X=300990 $Y=276965
X1779 640 98 8 550 14 INR2XD0BWP7T $T=306880 206640 1 0 $X=306590 $Y=202430
X1780 432 98 8 365 14 INR2XD0BWP7T $T=309120 222320 0 0 $X=308830 $Y=222085
X1781 1875 417 8 1865 14 INR2XD0BWP7T $T=311920 120400 0 0 $X=311630 $Y=120165
X1782 1712 98 8 548 14 INR2XD0BWP7T $T=314720 222320 1 180 $X=311630 $Y=222085
X1783 1815 100 8 549 14 INR2XD0BWP7T $T=312480 285040 1 0 $X=312190 $Y=280830
X1784 1832 417 8 1890 14 INR2XD0BWP7T $T=314720 120400 0 0 $X=314430 $Y=120165
X1785 1921 1214 8 320 14 INR2XD0BWP7T $T=317520 355600 0 180 $X=314430 $Y=351390
X1786 1886 417 8 1891 14 INR2XD0BWP7T $T=315840 128240 0 0 $X=315550 $Y=128005
X1787 1808 100 8 568 14 INR2XD0BWP7T $T=318080 285040 1 0 $X=317790 $Y=280830
X1788 1719 100 8 323 14 INR2XD0BWP7T $T=319200 238000 1 0 $X=318910 $Y=233790
X1789 1795 100 8 324 14 INR2XD0BWP7T $T=319200 300720 1 0 $X=318910 $Y=296510
X1790 1943 417 8 1913 14 INR2XD0BWP7T $T=323120 104720 0 180 $X=320030 $Y=100510
X1791 1932 417 8 1914 14 INR2XD0BWP7T $T=323120 120400 1 180 $X=320030 $Y=120165
X1792 1892 417 8 1922 14 INR2XD0BWP7T $T=323680 128240 1 180 $X=320590 $Y=128005
X1793 432 100 8 569 14 INR2XD0BWP7T $T=327600 222320 0 0 $X=327310 $Y=222085
X1794 640 100 8 381 14 INR2XD0BWP7T $T=327600 245840 1 0 $X=327310 $Y=241630
X1795 1422 100 8 496 14 INR2XD0BWP7T $T=330960 277200 1 180 $X=327870 $Y=276965
X1796 1956 417 8 1941 14 INR2XD0BWP7T $T=331520 96880 1 180 $X=328430 $Y=96645
X1797 1928 100 8 570 14 INR2XD0BWP7T $T=329840 308560 0 0 $X=329550 $Y=308325
X1798 1553 100 8 327 14 INR2XD0BWP7T $T=329840 332080 1 0 $X=329550 $Y=327870
X1799 1982 417 8 1949 14 INR2XD0BWP7T $T=333760 104720 0 180 $X=330670 $Y=100510
X1800 1970 438 8 330 14 INR2XD0BWP7T $T=335440 339920 1 0 $X=335150 $Y=335710
X1801 388 1874 8 336 14 INR2XD0BWP7T $T=337120 159600 0 0 $X=336830 $Y=159365
X1802 1433 417 8 1942 14 INR2XD0BWP7T $T=341600 120400 1 180 $X=338510 $Y=120165
X1803 2003 438 8 331 14 INR2XD0BWP7T $T=341600 324240 1 180 $X=338510 $Y=324005
X1804 2073 438 8 334 14 INR2XD0BWP7T $T=356720 339920 0 180 $X=353630 $Y=335710
X1805 2033 2051 8 2064 14 INR2XD0BWP7T $T=357840 347760 0 180 $X=354750 $Y=343550
X1806 119 100 8 625 14 INR2XD0BWP7T $T=360080 269360 1 180 $X=356990 $Y=269125
X1807 input_select_dbg 100 8 343 14 INR2XD0BWP7T $T=360080 292880 0 0 $X=359790 $Y=292645
X1808 mode_select_dbg 100 8 571 14 INR2XD0BWP7T $T=360640 316400 1 0 $X=360350 $Y=312190
X1809 2086 438 8 340 14 INR2XD0BWP7T $T=362320 332080 1 0 $X=362030 $Y=327870
X1810 2118 2113 8 2123 14 INR2XD0BWP7T $T=370160 222320 0 0 $X=369870 $Y=222085
X1811 2121 2119 8 2130 14 INR2XD0BWP7T $T=378560 308560 1 180 $X=375470 $Y=308325
X1812 2156 630 8 453 14 INR2XD0BWP7T $T=392000 214480 0 0 $X=391710 $Y=214245
X1813 2154 630 8 393 14 INR2XD0BWP7T $T=392000 245840 1 0 $X=391710 $Y=241630
X1814 2159 630 8 474 14 INR2XD0BWP7T $T=392560 238000 1 0 $X=392270 $Y=233790
X1815 2161 630 8 358 14 INR2XD0BWP7T $T=397040 222320 1 180 $X=393950 $Y=222085
X1830 794 223 224 8 587 14 DFKCNQD1BWP7T $T=101920 269360 0 0 $X=101630 $Y=269125
X1831 794 223 225 8 581 14 DFKCNQD1BWP7T $T=106400 285040 1 0 $X=106110 $Y=280830
X1832 821 223 226 8 845 14 DFKCNQD1BWP7T $T=106400 300720 1 0 $X=106110 $Y=296510
X1833 821 223 227 8 863 14 DFKCNQD1BWP7T $T=108080 316400 0 0 $X=107790 $Y=316165
X1834 830 223 228 8 872 14 DFKCNQD1BWP7T $T=109200 292880 1 0 $X=108910 $Y=288670
X1835 830 223 229 8 893 14 DFKCNQD1BWP7T $T=117600 285040 1 0 $X=117310 $Y=280830
X1836 821 223 230 8 925 14 DFKCNQD1BWP7T $T=129920 316400 0 0 $X=129630 $Y=316165
X1837 836 223 231 8 665 14 DFKCNQD1BWP7T $T=131040 238000 1 0 $X=130750 $Y=233790
X1838 916 232 233 8 936 14 DFKCNQD1BWP7T $T=148400 355600 0 180 $X=136910 $Y=351390
X1839 968 234 235 8 1001 14 DFKCNQD1BWP7T $T=143920 198800 1 0 $X=143630 $Y=194590
X1840 968 236 237 8 998 14 DFKCNQD1BWP7T $T=144480 143920 0 0 $X=144190 $Y=143685
X1841 916 223 238 8 970 14 DFKCNQD1BWP7T $T=155680 324240 1 180 $X=144190 $Y=324005
X1842 968 234 239 8 1006 14 DFKCNQD1BWP7T $T=145040 159600 0 0 $X=144750 $Y=159365
X1843 972 234 239 8 404 14 DFKCNQD1BWP7T $T=145040 167440 1 0 $X=144750 $Y=163230
X1844 968 234 240 8 973 14 DFKCNQD1BWP7T $T=156240 190960 1 180 $X=144750 $Y=190725
X1845 836 234 241 8 595 14 DFKCNQD1BWP7T $T=145040 238000 1 0 $X=144750 $Y=233790
X1846 830 223 242 8 997 14 DFKCNQD1BWP7T $T=145040 261520 1 0 $X=144750 $Y=257310
X1847 916 232 243 8 1048 14 DFKCNQD1BWP7T $T=157920 355600 1 0 $X=157630 $Y=351390
X1848 916 232 244 8 980 14 DFKCNQD1BWP7T $T=169120 363440 1 180 $X=157630 $Y=363205
X1849 1075 232 245 8 1023 14 DFKCNQD1BWP7T $T=169680 347760 0 180 $X=158190 $Y=343550
X1850 1022 236 239 8 1088 14 DFKCNQD1BWP7T $T=159040 151760 1 0 $X=158750 $Y=147550
X1851 1075 232 246 8 1040 14 DFKCNQD1BWP7T $T=171920 324240 0 180 $X=160430 $Y=320030
X1852 1138 234 247 8 1074 14 DFKCNQD1BWP7T $T=179760 238000 1 180 $X=168270 $Y=237765
X1853 1022 236 248 8 1151 14 DFKCNQD1BWP7T $T=170240 151760 1 0 $X=169950 $Y=147550
X1854 1022 236 237 8 1155 14 DFKCNQD1BWP7T $T=171360 159600 1 0 $X=171070 $Y=155390
X1855 972 234 240 8 755 14 DFKCNQD1BWP7T $T=171920 183120 1 0 $X=171630 $Y=178910
X1856 972 234 249 8 506 14 DFKCNQD1BWP7T $T=183680 167440 1 180 $X=172190 $Y=167205
X1857 1113 234 240 8 1143 14 DFKCNQD1BWP7T $T=173040 183120 0 0 $X=172750 $Y=182885
X1858 1070 234 250 8 1232 14 DFKCNQD1BWP7T $T=185920 190960 0 0 $X=185630 $Y=190725
X1859 1228 232 251 8 1092 14 DFKCNQD1BWP7T $T=197120 324240 0 180 $X=185630 $Y=320030
X1860 1075 232 252 8 1167 14 DFKCNQD1BWP7T $T=185920 324240 0 0 $X=185630 $Y=324005
X1861 1229 232 253 8 1148 14 DFKCNQD1BWP7T $T=197120 339920 0 180 $X=185630 $Y=335710
X1862 1075 232 254 8 1139 14 DFKCNQD1BWP7T $T=185920 363440 0 0 $X=185630 $Y=363205
X1863 1113 234 255 8 1184 14 DFKCNQD1BWP7T $T=198240 183120 0 180 $X=186750 $Y=178910
X1864 1183 236 255 8 405 14 DFKCNQD1BWP7T $T=199360 151760 1 180 $X=187870 $Y=151525
X1865 1228 223 256 8 1196 14 DFKCNQD1BWP7T $T=200480 285040 1 180 $X=188990 $Y=284805
X1866 1203 232 257 8 583 14 DFKCNQD1BWP7T $T=191520 386960 1 0 $X=191230 $Y=382750
X1867 1203 232 258 8 588 14 DFKCNQD1BWP7T $T=191520 394800 1 0 $X=191230 $Y=390590
X1868 1229 232 259 8 1161 14 DFKCNQD1BWP7T $T=208320 324240 0 180 $X=196830 $Y=320030
X1869 1070 236 260 8 1231 14 DFKCNQD1BWP7T $T=209440 143920 1 180 $X=197950 $Y=143685
X1870 1113 234 261 8 1277 14 DFKCNQD1BWP7T $T=199360 167440 1 0 $X=199070 $Y=163230
X1871 1113 234 262 8 778 14 DFKCNQD1BWP7T $T=199360 175280 0 0 $X=199070 $Y=175045
X1872 1229 232 263 8 1296 14 DFKCNQD1BWP7T $T=201040 332080 0 0 $X=200750 $Y=331845
X1873 1229 232 264 8 1123 14 DFKCNQD1BWP7T $T=212800 339920 1 180 $X=201310 $Y=339685
X1874 1113 236 260 8 779 14 DFKCNQD1BWP7T $T=213920 151760 1 0 $X=213630 $Y=147550
X1875 1366 265 266 8 1310 14 DFKCNQD1BWP7T $T=225120 167440 0 180 $X=213630 $Y=163230
X1876 1315 232 267 8 1309 14 DFKCNQD1BWP7T $T=213920 316400 0 0 $X=213630 $Y=316165
X1877 1368 232 268 8 1292 14 DFKCNQD1BWP7T $T=225120 363440 1 180 $X=213630 $Y=363205
X1878 1203 232 269 8 1302 14 DFKCNQD1BWP7T $T=215040 347760 1 0 $X=214750 $Y=343550
X1879 1183 73 270 8 401 14 DFKCNQD1BWP7T $T=226800 143920 1 180 $X=215310 $Y=143685
X1880 1384 73 270 8 1308 14 DFKCNQD1BWP7T $T=227360 136080 0 180 $X=215870 $Y=131870
X1881 1368 232 271 8 1316 14 DFKCNQD1BWP7T $T=227360 363440 0 180 $X=215870 $Y=359230
X1882 1315 232 272 8 1334 14 DFKCNQD1BWP7T $T=229040 332080 1 180 $X=217550 $Y=331845
X1883 1180 92 273 8 1393 14 DFKCNQD1BWP7T $T=218400 198800 1 0 $X=218110 $Y=194590
X1884 1315 232 274 8 1298 14 DFKCNQD1BWP7T $T=231280 300720 1 180 $X=219790 $Y=300485
X1885 1229 232 275 8 1268 14 DFKCNQD1BWP7T $T=232400 339920 1 180 $X=220910 $Y=339685
X1886 1368 232 276 8 1258 14 DFKCNQD1BWP7T $T=232400 394800 1 180 $X=220910 $Y=394565
X1887 1313 92 277 8 408 14 DFKCNQD1BWP7T $T=239680 238000 1 180 $X=228190 $Y=237765
X1888 1314 92 278 8 1306 14 DFKCNQD1BWP7T $T=240800 261520 0 180 $X=229310 $Y=257310
X1889 1314 92 279 8 1282 14 DFKCNQD1BWP7T $T=240800 292880 0 180 $X=229310 $Y=288670
X1890 1537 232 280 8 585 14 DFKCNQD1BWP7T $T=253120 371280 0 180 $X=241630 $Y=367070
X1891 1314 92 281 8 1351 14 DFKCNQD1BWP7T $T=253680 261520 1 180 $X=242190 $Y=261285
X1892 1314 92 282 8 1311 14 DFKCNQD1BWP7T $T=254800 261520 0 180 $X=243310 $Y=257310
X1893 1555 283 284 8 1458 14 DFKCNQD1BWP7T $T=255360 316400 0 180 $X=243870 $Y=312190
X1894 1557 283 285 8 1484 14 DFKCNQD1BWP7T $T=255360 355600 0 180 $X=243870 $Y=351390
X1895 94 92 286 8 522 14 DFKCNQD1BWP7T $T=257040 277200 0 180 $X=245550 $Y=272990
X1896 1313 92 287 8 1312 14 DFKCNQD1BWP7T $T=246400 238000 0 0 $X=246110 $Y=237765
X1897 1557 283 288 8 777 14 DFKCNQD1BWP7T $T=257600 339920 1 180 $X=246110 $Y=339685
X1898 1537 232 289 8 669 14 DFKCNQD1BWP7T $T=260400 363440 0 180 $X=248910 $Y=359230
X1899 1555 283 290 8 776 14 DFKCNQD1BWP7T $T=262080 316400 1 180 $X=250590 $Y=316165
X1900 1561 283 291 8 1599 14 DFKCNQD1BWP7T $T=254240 339920 1 0 $X=253950 $Y=335710
X1901 1368 232 292 8 76 14 DFKCNQD1BWP7T $T=256480 394800 1 0 $X=256190 $Y=390590
X1902 1384 73 293 8 1637 14 DFKCNQD1BWP7T $T=257040 143920 1 0 $X=256750 $Y=139710
X1903 1583 92 294 8 1636 14 DFKCNQD1BWP7T $T=257600 222320 0 0 $X=257310 $Y=222085
X1904 1313 92 295 8 419 14 DFKCNQD1BWP7T $T=257600 238000 0 0 $X=257310 $Y=237765
X1905 1571 283 296 8 1526 14 DFKCNQD1BWP7T $T=268800 332080 0 180 $X=257310 $Y=327870
X1906 1548 297 298 8 1405 14 DFKCNQD1BWP7T $T=281120 136080 0 180 $X=269630 $Y=131870
X1907 1641 92 299 8 422 14 DFKCNQD1BWP7T $T=281120 277200 0 180 $X=269630 $Y=272990
X1908 1384 73 300 8 1685 14 DFKCNQD1BWP7T $T=271040 143920 1 0 $X=270750 $Y=139710
X1909 94 92 301 8 1628 14 DFKCNQD1BWP7T $T=282240 230160 0 180 $X=270750 $Y=225950
X1910 1537 283 302 8 1604 14 DFKCNQD1BWP7T $T=282800 371280 0 180 $X=271310 $Y=367070
X1911 1641 92 303 8 640 14 DFKCNQD1BWP7T $T=272720 245840 0 0 $X=272430 $Y=245605
X1912 1571 283 304 8 1730 14 DFKCNQD1BWP7T $T=272720 316400 0 0 $X=272430 $Y=316165
X1913 1641 92 305 8 432 14 DFKCNQD1BWP7T $T=276080 245840 1 0 $X=275790 $Y=241630
X1914 1561 283 306 8 1765 14 DFKCNQD1BWP7T $T=277760 339920 0 0 $X=277470 $Y=339685
X1915 1641 92 307 8 1719 14 DFKCNQD1BWP7T $T=278320 277200 0 0 $X=278030 $Y=276965
X1916 1384 297 308 8 1806 14 DFKCNQD1BWP7T $T=285040 136080 1 0 $X=284750 $Y=131870
X1917 1583 92 309 8 1802 14 DFKCNQD1BWP7T $T=285600 238000 1 0 $X=285310 $Y=233790
X1918 1366 139 308 8 1833 14 DFKCNQD1BWP7T $T=297920 159600 1 0 $X=297630 $Y=155390
X1919 1783 139 310 8 516 14 DFKCNQD1BWP7T $T=309120 167440 0 180 $X=297630 $Y=163230
X1920 1783 139 311 8 1667 14 DFKCNQD1BWP7T $T=309120 183120 0 180 $X=297630 $Y=178910
X1921 1583 92 312 8 1836 14 DFKCNQD1BWP7T $T=297920 222320 0 0 $X=297630 $Y=222085
X1922 1834 283 313 8 1808 14 DFKCNQD1BWP7T $T=309680 379120 0 180 $X=298190 $Y=374910
X1923 1783 139 314 8 730 14 DFKCNQD1BWP7T $T=310240 159600 1 180 $X=298750 $Y=159365
X1924 1461 139 315 8 1869 14 DFKCNQD1BWP7T $T=299040 206640 0 0 $X=298750 $Y=206405
X1925 1555 283 316 8 1803 14 DFKCNQD1BWP7T $T=310240 300720 1 180 $X=298750 $Y=300485
X1926 1834 283 317 8 1815 14 DFKCNQD1BWP7T $T=311360 355600 0 180 $X=299870 $Y=351390
X1927 1537 283 318 8 732 14 DFKCNQD1BWP7T $T=300720 363440 1 0 $X=300430 $Y=359230
X1928 1783 139 319 8 1364 14 DFKCNQD1BWP7T $T=320320 183120 0 180 $X=308830 $Y=178910
X1929 1834 283 320 8 1422 14 DFKCNQD1BWP7T $T=310240 355600 0 0 $X=309950 $Y=355365
X1930 1863 139 321 8 input_select_dbg 14 DFKCNQD1BWP7T $T=311920 198800 1 0 $X=311630 $Y=194590
X1931 1863 139 322 8 790 14 DFKCNQD1BWP7T $T=323680 183120 1 180 $X=312190 $Y=182885
X1932 1878 139 323 8 1933 14 DFKCNQD1BWP7T $T=313040 238000 0 0 $X=312750 $Y=237765
X1933 1822 283 324 8 1931 14 DFKCNQD1BWP7T $T=313600 308560 1 0 $X=313310 $Y=304350
X1934 1557 283 325 8 729 14 DFKCNQD1BWP7T $T=324800 339920 0 180 $X=313310 $Y=335710
X1935 1843 139 311 8 580 14 DFKCNQD1BWP7T $T=325920 159600 0 0 $X=325630 $Y=159365
X1936 1863 139 326 8 1957 14 DFKCNQD1BWP7T $T=325920 167440 1 0 $X=325630 $Y=163230
X1937 1822 283 327 8 1981 14 DFKCNQD1BWP7T $T=327600 324240 0 0 $X=327310 $Y=324005
X1938 1878 139 328 8 1989 14 DFKCNQD1BWP7T $T=328160 230160 0 0 $X=327870 $Y=229925
X1939 1834 283 329 8 518 14 DFKCNQD1BWP7T $T=339360 363440 0 180 $X=327870 $Y=359230
X1940 1927 283 330 8 1960 14 DFKCNQD1BWP7T $T=334320 339920 0 0 $X=334030 $Y=339685
X1941 1927 265 331 8 2005 14 DFKCNQD1BWP7T $T=337120 324240 1 0 $X=336830 $Y=320030
X1942 1843 139 321 8 2042 14 DFKCNQD1BWP7T $T=341040 190960 1 0 $X=340750 $Y=186750
X1943 1843 139 319 8 2060 14 DFKCNQD1BWP7T $T=341600 175280 1 0 $X=341310 $Y=171070
X1944 1843 139 322 8 2056 14 DFKCNQD1BWP7T $T=341600 175280 0 0 $X=341310 $Y=175045
X1945 2067 265 332 8 2007 14 DFKCNQD1BWP7T $T=352800 292880 1 180 $X=341310 $Y=292645
X1946 1927 265 333 8 2050 14 DFKCNQD1BWP7T $T=341600 324240 0 0 $X=341310 $Y=324005
X1947 1927 265 334 8 604 14 DFKCNQD1BWP7T $T=341600 332080 0 0 $X=341310 $Y=331845
X1948 2072 297 335 8 2084 14 DFKCNQD1BWP7T $T=353920 136080 0 0 $X=353630 $Y=135845
X1949 94 139 336 8 2103 14 DFKCNQD1BWP7T $T=353920 167440 1 0 $X=353630 $Y=163230
X1950 2098 139 337 8 1984 14 DFKCNQD1BWP7T $T=365120 214480 1 180 $X=353630 $Y=214245
X1951 2067 265 338 8 2059 14 DFKCNQD1BWP7T $T=365120 308560 0 180 $X=353630 $Y=304350
X1952 2116 265 339 8 2068 14 DFKCNQD1BWP7T $T=369600 245840 1 180 $X=358110 $Y=245605
X1953 1927 265 340 8 2078 14 DFKCNQD1BWP7T $T=369600 324240 1 180 $X=358110 $Y=324005
X1954 1927 265 341 8 602 14 DFKCNQD1BWP7T $T=369600 332080 1 180 $X=358110 $Y=331845
X1955 2067 265 342 8 2049 14 DFKCNQD1BWP7T $T=371840 277200 1 180 $X=360350 $Y=276965
X1956 2067 265 343 8 2091 14 DFKCNQD1BWP7T $T=362880 300720 0 0 $X=362590 $Y=300485
X1957 2072 139 344 8 500 14 DFKCNQD1BWP7T $T=367920 136080 0 0 $X=367630 $Y=135845
X1958 2072 139 345 8 2104 14 DFKCNQD1BWP7T $T=379120 143920 0 180 $X=367630 $Y=139710
X1959 125 139 346 8 2135 14 DFKCNQD1BWP7T $T=369600 159600 1 0 $X=369310 $Y=155390
X1960 2116 265 347 8 2109 14 DFKCNQD1BWP7T $T=380800 245840 1 180 $X=369310 $Y=245605
X1961 2139 265 348 8 2083 14 DFKCNQD1BWP7T $T=380800 332080 1 180 $X=369310 $Y=331845
X1962 142 139 349 8 504 14 DFKCNQD1BWP7T $T=393120 190960 0 180 $X=381630 $Y=186750
X1963 2139 265 350 8 2071 14 DFKCNQD1BWP7T $T=381920 261520 0 0 $X=381630 $Y=261285
X1964 2139 265 351 8 118 14 DFKCNQD1BWP7T $T=381920 269360 0 0 $X=381630 $Y=269125
X1965 2139 265 352 8 2132 14 DFKCNQD1BWP7T $T=381920 285040 1 0 $X=381630 $Y=280830
X1966 2139 265 353 8 2079 14 DFKCNQD1BWP7T $T=381920 332080 1 0 $X=381630 $Y=327870
X1967 2098 139 354 8 2006 14 DFKCNQD1BWP7T $T=394240 206640 1 180 $X=382750 $Y=206405
X1968 125 139 355 8 2160 14 DFKCNQD1BWP7T $T=383600 175280 0 0 $X=383310 $Y=175045
X1969 125 139 356 8 2150 14 DFKCNQD1BWP7T $T=397600 175280 0 180 $X=386110 $Y=171070
X1970 125 139 357 8 2151 14 DFKCNQD1BWP7T $T=398160 159600 1 180 $X=386670 $Y=159365
X1971 2098 139 358 8 2036 14 DFKCNQD1BWP7T $T=401520 222320 0 180 $X=390030 $Y=218110
X1972 223 359 14 8 821 857 ICV_60 $T=106400 300720 0 0 $X=106110 $Y=300485
X1973 223 360 14 8 836 399 ICV_60 $T=111440 238000 1 0 $X=111150 $Y=233790
X1974 223 361 14 8 794 586 ICV_60 $T=112000 277200 0 0 $X=111710 $Y=276965
X1975 223 362 14 8 830 949 ICV_60 $T=141120 277200 1 0 $X=140830 $Y=272990
X1976 234 250 14 8 1022 1124 ICV_60 $T=169120 198800 1 0 $X=168830 $Y=194590
X1977 234 262 14 8 1183 509 ICV_60 $T=187040 159600 0 0 $X=186750 $Y=159365
X1978 232 363 14 8 1203 590 ICV_60 $T=189840 347760 0 0 $X=189550 $Y=347525
X1979 234 364 14 8 1180 1304 ICV_60 $T=197120 190960 0 0 $X=196830 $Y=190725
X1980 236 260 14 8 1183 54 ICV_60 $T=213920 159600 1 0 $X=213630 $Y=155390
X1981 139 365 14 8 1796 1918 ICV_60 $T=307440 222320 1 0 $X=307150 $Y=218110
X1982 283 366 14 8 1927 600 ICV_60 $T=333200 347760 1 0 $X=332910 $Y=343550
X1983 139 367 14 8 142 2163 ICV_60 $T=392560 190960 0 0 $X=392270 $Y=190725
X1984 139 368 14 8 142 2157 ICV_60 $T=393120 190960 1 0 $X=392830 $Y=186750
X1985 31 32 8 813 14 NR2XD0BWP7T $T=107520 253680 1 180 $X=104990 $Y=253445
X1986 818 819 8 802 14 NR2XD0BWP7T $T=108080 175280 0 180 $X=105550 $Y=171070
X1987 747 400 8 877 14 NR2XD0BWP7T $T=123200 300720 0 180 $X=120670 $Y=296510
X1988 885 400 8 870 14 NR2XD0BWP7T $T=123200 308560 0 180 $X=120670 $Y=304350
X1989 755 754 8 913 14 NR2XD0BWP7T $T=136080 183120 1 180 $X=133550 $Y=182885
X1990 954 44 8 946 14 NR2XD0BWP7T $T=142240 175280 0 180 $X=139710 $Y=171070
X1991 749 407 8 988 14 NR2XD0BWP7T $T=151760 355600 1 0 $X=151470 $Y=351390
X1992 995 407 8 1002 14 NR2XD0BWP7T $T=155680 339920 1 180 $X=153150 $Y=339685
X1993 753 183 8 1257 14 NR2XD0BWP7T $T=206640 386960 0 180 $X=204110 $Y=382750
X1994 756 409 8 1356 14 NR2XD0BWP7T $T=227360 277200 1 180 $X=224830 $Y=276965
X1995 1357 409 8 1401 14 NR2XD0BWP7T $T=227360 292880 1 0 $X=227070 $Y=288670
X1996 57 704 8 1416 14 NR2XD0BWP7T $T=233520 167440 0 180 $X=230990 $Y=163230
X1997 572 busy 8 1455 14 NR2XD0BWP7T $T=238560 222320 1 0 $X=238270 $Y=218110
X1998 730 421 8 1608 14 NR2XD0BWP7T $T=264880 175280 1 0 $X=264590 $Y=171070
X1999 1638 1635 8 1629 14 NR2XD0BWP7T $T=268800 96880 0 180 $X=266270 $Y=92670
X2000 417 1762 8 1777 14 NR2XD0BWP7T $T=288960 89040 1 0 $X=288670 $Y=84830
X2001 1719 1214 8 307 14 NR2XD0BWP7T $T=292320 277200 1 180 $X=289790 $Y=276965
X2002 417 1793 8 1785 14 NR2XD0BWP7T $T=295680 104720 1 180 $X=293150 $Y=104485
X2003 417 1821 8 1858 14 NR2XD0BWP7T $T=299600 89040 0 0 $X=299310 $Y=88805
X2004 1617 437 8 1897 14 NR2XD0BWP7T $T=312480 104720 0 0 $X=312190 $Y=104485
X2005 1908 417 8 1871 14 NR2XD0BWP7T $T=322000 96880 1 180 $X=319470 $Y=96645
X2006 1936 417 8 1883 14 NR2XD0BWP7T $T=328720 96880 1 0 $X=328430 $Y=92670
X2007 1928 1214 8 391 14 NR2XD0BWP7T $T=332080 355600 0 0 $X=331790 $Y=355365
X2008 101 107 8 2032 14 NR2XD0BWP7T $T=347760 159600 1 0 $X=347470 $Y=155390
X2009 2043 2051 8 2063 14 NR2XD0BWP7T $T=348880 347760 1 0 $X=348590 $Y=343550
X2010 2050 438 8 333 14 NR2XD0BWP7T $T=352240 324240 0 180 $X=349710 $Y=320030
X2011 2115 2113 8 2108 14 NR2XD0BWP7T $T=367920 222320 0 180 $X=365390 $Y=218110
X2012 2133 2119 8 2120 14 NR2XD0BWP7T $T=377440 316400 0 180 $X=374910 $Y=312190
X2013 2065 630 8 482 14 NR2XD0BWP7T $T=390320 253680 1 0 $X=390030 $Y=249470
X2014 223 369 14 8 794 398 ICV_61 $T=104160 277200 1 0 $X=103870 $Y=272990
X2015 223 370 14 8 822 867 ICV_61 $T=106400 230160 0 0 $X=106110 $Y=229925
X2016 223 371 14 8 821 906 ICV_61 $T=115360 316400 1 0 $X=115070 $Y=312190
X2017 223 372 14 8 836 592 ICV_61 $T=129920 253680 1 0 $X=129630 $Y=249470
X2018 223 373 14 8 830 975 ICV_61 $T=134400 285040 1 0 $X=134110 $Y=280830
X2019 234 249 14 8 968 1011 ICV_61 $T=143920 206640 1 0 $X=143630 $Y=202430
X2020 223 374 14 8 821 771 ICV_61 $T=160160 308560 1 0 $X=159870 $Y=304350
X2021 236 261 14 8 1183 510 ICV_61 $T=185920 159600 1 0 $X=185630 $Y=155390
X2022 236 266 14 8 1070 1269 ICV_61 $T=198240 151760 1 0 $X=197950 $Y=147550
X2023 92 375 14 8 1314 1365 ICV_61 $T=213920 261520 1 0 $X=213630 $Y=257310
X2024 232 376 14 8 1315 1442 ICV_61 $T=229040 332080 0 0 $X=228750 $Y=331845
X2025 92 377 14 8 1561 1506 ICV_61 $T=257040 277200 1 0 $X=256750 $Y=272990
X2026 92 378 14 8 1461 1676 ICV_61 $T=269920 214480 1 0 $X=269630 $Y=210270
X2027 92 379 14 8 1641 424 ICV_61 $T=269920 269360 1 0 $X=269630 $Y=265150
X2028 92 380 14 8 1641 688 ICV_61 $T=276080 269360 0 0 $X=275790 $Y=269125
X2029 139 326 14 8 1843 1951 ICV_61 $T=325920 159600 1 0 $X=325630 $Y=155390
X2030 139 381 14 8 1878 1991 ICV_61 $T=325920 238000 0 0 $X=325630 $Y=237765
X2031 139 382 14 8 1863 2001 ICV_61 $T=328160 175280 1 0 $X=327870 $Y=171070
X2032 139 310 14 8 1863 527 ICV_61 $T=328160 175280 0 0 $X=327870 $Y=175045
X2033 139 319 14 8 1863 inject_error_enable_dbg ICV_61 $T=328160 190960 1 0 $X=327870 $Y=186750
X2034 283 383 14 8 1822 1997 ICV_61 $T=328160 316400 0 0 $X=327870 $Y=316165
X2035 139 384 14 8 142 2162 ICV_61 $T=390320 206640 1 0 $X=390030 $Y=202430
X2324 234 385 14 8 1138 1052 ICV_66 $T=166880 222320 1 0 $X=166590 $Y=218110
X2325 234 255 14 8 1070 1178 ICV_66 $T=185920 183120 0 0 $X=185630 $Y=182885
X2326 265 266 14 8 1183 954 ICV_66 $T=197680 159600 1 0 $X=197390 $Y=155390
X2327 232 386 14 8 1368 670 ICV_66 $T=227360 363440 1 0 $X=227070 $Y=359230
X2328 232 387 14 8 1368 74 ICV_66 $T=241920 386960 0 0 $X=241630 $Y=386725
X2329 73 388 14 8 1548 430 ICV_66 $T=269920 159600 1 0 $X=269630 $Y=155390
X2330 73 389 14 8 1548 1490 ICV_66 $T=272160 167440 1 0 $X=271870 $Y=163230
X2331 297 308 14 8 1548 1497 ICV_66 $T=283360 159600 1 0 $X=283070 $Y=155390
X2332 139 314 14 8 1843 1818 ICV_66 $T=297920 151760 1 0 $X=297630 $Y=147550
X2333 283 390 14 8 1834 1795 ICV_66 $T=297920 371280 0 0 $X=297630 $Y=371045
X2334 283 391 14 8 1834 1928 ICV_66 $T=325920 355600 1 0 $X=325630 $Y=351390
X2335 139 392 14 8 2098 2002 ICV_66 $T=366240 206640 0 0 $X=365950 $Y=206405
X2336 265 393 14 8 2098 2024 ICV_66 $T=386400 245840 0 0 $X=386110 $Y=245605
X2337 394 8 799 14 INVD1BWP7T $T=99120 198800 1 180 $X=97150 $Y=198565
X2338 395 8 800 14 INVD1BWP7T $T=99680 190960 0 180 $X=97710 $Y=186750
X2339 24 8 811 14 INVD1BWP7T $T=105840 183120 0 0 $X=105550 $Y=182885
X2340 396 8 826 14 INVD1BWP7T $T=118160 159600 1 180 $X=116190 $Y=159365
X2341 397 8 876 14 INVD1BWP7T $T=119840 159600 1 0 $X=119550 $Y=155390
X2342 398 8 38 14 INVD1BWP7T $T=120400 198800 1 0 $X=120110 $Y=194590
X2343 399 8 733 14 INVD1BWP7T $T=122640 198800 1 180 $X=120670 $Y=198565
X2344 42 8 890 14 INVD1BWP7T $T=127120 198800 0 180 $X=125150 $Y=194590
X2345 400 8 900 14 INVD1BWP7T $T=128240 300720 0 180 $X=126270 $Y=296510
X2346 401 8 29 14 INVD1BWP7T $T=134400 190960 0 180 $X=132430 $Y=186750
X2347 402 8 892 14 INVD1BWP7T $T=135520 151760 0 180 $X=133550 $Y=147550
X2348 54 8 887 14 INVD1BWP7T $T=135520 159600 0 180 $X=133550 $Y=155390
X2349 403 8 931 14 INVD1BWP7T $T=140000 190960 0 180 $X=138030 $Y=186750
X2350 404 8 41 14 INVD1BWP7T $T=140560 167440 0 180 $X=138590 $Y=163230
X2351 405 8 907 14 INVD1BWP7T $T=142800 151760 0 180 $X=140830 $Y=147550
X2352 406 8 607 14 INVD1BWP7T $T=143360 214480 0 180 $X=141390 $Y=210270
X2353 32 8 958 14 INVD1BWP7T $T=147280 253680 0 180 $X=145310 $Y=249470
X2354 407 8 1017 14 INVD1BWP7T $T=154560 347760 0 0 $X=154270 $Y=347525
X2355 183 8 1381 14 INVD1BWP7T $T=225120 379120 1 0 $X=224830 $Y=374910
X2356 57 8 1419 14 INVD1BWP7T $T=229600 159600 1 0 $X=229310 $Y=155390
X2357 408 8 1402 14 INVD1BWP7T $T=232960 190960 0 180 $X=230990 $Y=186750
X2358 409 8 1396 14 INVD1BWP7T $T=231280 300720 0 0 $X=230990 $Y=300485
X2359 56 8 1425 14 INVD1BWP7T $T=232400 151760 0 0 $X=232110 $Y=151525
X2360 198 8 1046 14 INVD1BWP7T $T=235200 206640 1 0 $X=234910 $Y=202430
X2361 410 8 739 14 INVD1BWP7T $T=237440 190960 0 180 $X=235470 $Y=186750
X2362 411 8 1432 14 INVD1BWP7T $T=238000 175280 0 180 $X=236030 $Y=171070
X2363 412 8 58 14 INVD1BWP7T $T=238560 222320 0 180 $X=236590 $Y=218110
X2364 413 8 1446 14 INVD1BWP7T $T=244720 175280 0 180 $X=242750 $Y=171070
X2365 414 8 1486 14 INVD1BWP7T $T=249760 89040 1 180 $X=247790 $Y=88805
X2366 415 8 1404 14 INVD1BWP7T $T=250880 222320 1 180 $X=248910 $Y=222085
X2367 66 8 1507 14 INVD1BWP7T $T=251440 159600 1 180 $X=249470 $Y=159365
X2368 84 8 1511 14 INVD1BWP7T $T=254800 120400 1 0 $X=254510 $Y=116190
X2369 416 8 1580 14 INVD1BWP7T $T=260400 175280 0 180 $X=258430 $Y=171070
X2370 417 8 1600 14 INVD1BWP7T $T=260960 104720 0 0 $X=260670 $Y=104485
X2371 418 8 1568 14 INVD1BWP7T $T=264320 198800 0 180 $X=262350 $Y=194590
X2372 419 8 741 14 INVD1BWP7T $T=265440 214480 1 180 $X=263470 $Y=214245
X2373 420 8 1575 14 INVD1BWP7T $T=266560 96880 0 180 $X=264590 $Y=92670
X2374 421 8 1540 14 INVD1BWP7T $T=266560 167440 1 180 $X=264590 $Y=167205
X2375 422 8 1611 14 INVD1BWP7T $T=272720 206640 1 180 $X=270750 $Y=206405
X2376 423 8 1664 14 INVD1BWP7T $T=274400 253680 0 180 $X=272430 $Y=249470
X2377 424 8 1679 14 INVD1BWP7T $T=274400 206640 0 0 $X=274110 $Y=206405
X2378 425 8 1693 14 INVD1BWP7T $T=278880 190960 0 180 $X=276910 $Y=186750
X2379 426 8 1717 14 INVD1BWP7T $T=278880 175280 0 0 $X=278590 $Y=175045
X2380 427 8 96 14 INVD1BWP7T $T=281120 222320 1 0 $X=280830 $Y=218110
X2381 428 8 1732 14 INVD1BWP7T $T=282240 183120 1 0 $X=281950 $Y=178910
X2382 429 8 1739 14 INVD1BWP7T $T=285600 245840 1 180 $X=283630 $Y=245605
X2383 430 8 1738 14 INVD1BWP7T $T=288960 222320 0 180 $X=286990 $Y=218110
X2384 431 8 1768 14 INVD1BWP7T $T=287840 190960 1 0 $X=287550 $Y=186750
X2385 432 8 638 14 INVD1BWP7T $T=290640 222320 0 180 $X=288670 $Y=218110
X2386 433 8 1716 14 INVD1BWP7T $T=292880 175280 0 180 $X=290910 $Y=171070
X2387 434 8 1778 14 INVD1BWP7T $T=297920 183120 0 0 $X=297630 $Y=182885
X2388 435 8 301 14 INVD1BWP7T $T=303520 230160 0 180 $X=301550 $Y=225950
X2389 436 8 1845 14 INVD1BWP7T $T=302400 371280 1 0 $X=302110 $Y=367070
X2390 437 8 1665 14 INVD1BWP7T $T=311920 112560 0 180 $X=309950 $Y=108350
X2391 438 8 286 14 INVD1BWP7T $T=321440 332080 1 180 $X=319470 $Y=331845
X2392 297 8 1935 14 INVD1BWP7T $T=327600 143920 0 0 $X=327310 $Y=143685
X2393 439 8 1967 14 INVD1BWP7T $T=332080 371280 1 0 $X=331790 $Y=367070
X2394 201 8 1642 14 INVD1BWP7T $T=338800 214480 0 0 $X=338510 $Y=214245
X2395 440 8 616 14 INVD1BWP7T $T=339920 143920 1 0 $X=339630 $Y=139710
X2396 441 8 1994 14 INVD1BWP7T $T=341600 332080 1 180 $X=339630 $Y=331845
X2397 103 8 2018 14 INVD1BWP7T $T=341040 190960 0 0 $X=340750 $Y=190725
X2398 99 8 697 14 INVD1BWP7T $T=343280 128240 0 180 $X=341310 $Y=124030
X2399 107 8 104 14 INVD1BWP7T $T=346640 128240 1 180 $X=344670 $Y=128005
X2400 442 8 2035 14 INVD1BWP7T $T=351680 190960 1 180 $X=349710 $Y=190725
X2401 443 8 2129 14 INVD1BWP7T $T=372400 324240 1 0 $X=372110 $Y=320030
X2402 135 8 134 14 INVD1BWP7T $T=378560 183120 0 180 $X=376590 $Y=178910
X2403 444 8 2128 14 INVD1BWP7T $T=378560 285040 0 180 $X=376590 $Y=280830
X2404 139 8 128 14 INVD1BWP7T $T=386400 183120 1 180 $X=384430 $Y=182885
X2405 445 8 2152 14 INVD1BWP7T $T=386400 230160 1 0 $X=386110 $Y=225950
X2406 223 446 14 8 836 664 ICV_67 $T=115360 245840 0 0 $X=115070 $Y=245605
X2407 234 447 14 8 1180 1188 ICV_67 $T=185920 206640 1 0 $X=185630 $Y=202430
X2408 73 293 14 8 1548 1450 ICV_67 $T=253680 143920 0 0 $X=253390 $Y=143685
X2409 73 389 14 8 1366 781 ICV_67 $T=269920 151760 1 0 $X=269630 $Y=147550
X2410 283 448 14 8 1571 727 ICV_67 $T=297920 324240 0 0 $X=297630 $Y=324005
X2411 283 449 14 8 1555 1784 ICV_67 $T=306320 324240 1 0 $X=306030 $Y=320030
X2412 283 450 14 8 1557 1700 ICV_67 $T=310240 332080 1 0 $X=309950 $Y=327870
X2413 265 prbs_out 14 8 94 2102 ICV_67 $T=365120 230160 1 0 $X=364830 $Y=225950
X2414 265 451 14 8 2116 2080 ICV_67 $T=365680 238000 1 0 $X=365390 $Y=233790
X2415 139 452 14 8 142 2107 ICV_67 $T=366240 190960 0 0 $X=365950 $Y=190725
X2416 139 453 14 8 2098 2040 ICV_67 $T=386400 214480 1 0 $X=386110 $Y=210270
X2417 234 454 14 8 1180 1204 ICV_68 $T=190400 198800 1 0 $X=190110 $Y=194590
X2418 232 455 14 8 1229 1150 ICV_68 $T=194880 347760 1 0 $X=194590 $Y=343550
X2419 92 456 14 8 1228 1211 ICV_68 $T=196000 261520 0 0 $X=195710 $Y=261285
X2420 232 457 14 8 1229 1168 ICV_68 $T=199920 324240 0 0 $X=199630 $Y=324005
X2421 232 458 14 8 1315 774 ICV_68 $T=222880 308560 1 0 $X=222590 $Y=304350
X2422 232 459 14 8 1368 645 ICV_68 $T=222880 394800 1 0 $X=222590 $Y=390590
X2423 73 460 14 8 1366 1470 ICV_68 $T=241920 143920 0 0 $X=241630 $Y=143685
X2424 92 461 14 8 1314 1328 ICV_68 $T=241920 285040 1 0 $X=241630 $Y=280830
X2425 283 462 14 8 1571 1499 ICV_68 $T=245840 332080 1 0 $X=245550 $Y=327870
X2426 283 463 14 8 1537 1579 ICV_68 $T=257040 363440 0 0 $X=256750 $Y=363205
X2427 283 464 14 8 1555 728 ICV_68 $T=301840 308560 1 0 $X=301550 $Y=304350
X2428 283 465 14 8 1557 1827 ICV_68 $T=306880 347760 0 0 $X=306590 $Y=347525
X2429 139 326 14 8 1783 757 ICV_68 $T=310240 167440 1 0 $X=309950 $Y=163230
X2430 283 466 14 8 1834 1553 ICV_68 $T=328160 379120 1 0 $X=327870 $Y=374910
X2431 139 467 14 8 2072 2088 ICV_68 $T=359520 151760 1 0 $X=359230 $Y=147550
X2432 139 468 14 8 125 2147 ICV_68 $T=386400 159600 1 0 $X=386110 $Y=155390
X2433 223 469 8 836 14 594 ICV_69 $T=137200 245840 1 0 $X=136910 $Y=241630
X2434 234 250 8 972 14 748 ICV_69 $T=169120 175280 0 0 $X=168830 $Y=175045
X2435 232 470 8 1075 14 1099 ICV_69 $T=169680 324240 0 0 $X=169390 $Y=324005
X2436 232 471 8 1228 14 1194 ICV_69 $T=189280 316400 0 0 $X=188990 $Y=316165
X2437 73 300 8 1366 14 780 ICV_69 $T=254240 151760 1 0 $X=253950 $Y=147550
X2438 73 300 8 1548 14 1475 ICV_69 $T=254800 151760 0 0 $X=254510 $Y=151525
X2439 283 472 8 1555 14 1621 ICV_69 $T=276640 308560 1 0 $X=276350 $Y=304350
X2440 283 473 8 1557 14 1820 ICV_69 $T=309680 347760 1 0 $X=309390 $Y=343550
X2441 265 474 8 2098 14 2054 ICV_69 $T=385840 238000 0 0 $X=385550 $Y=237765
X2442 158 591 792 8 806 14 HA1D0BWP7T $T=92400 253680 1 0 $X=92110 $Y=249470
X2443 825 394 829 8 803 14 HA1D0BWP7T $T=112000 238000 1 180 $X=103310 $Y=237765
X2444 813 587 823 8 809 14 HA1D0BWP7T $T=112560 261520 0 180 $X=103870 $Y=257310
X2445 824 664 820 8 856 14 HA1D0BWP7T $T=106960 245840 0 0 $X=106670 $Y=245605
X2446 870 857 852 8 837 14 HA1D0BWP7T $T=120960 308560 0 180 $X=112270 $Y=304350
X2447 854 586 842 8 878 14 HA1D0BWP7T $T=113680 269360 1 0 $X=113390 $Y=265150
X2448 880 668 905 8 868 14 HA1D0BWP7T $T=127680 261520 1 180 $X=118990 $Y=261285
X2449 877 872 858 8 902 14 HA1D0BWP7T $T=119280 292880 0 0 $X=118990 $Y=292645
X2450 900 893 908 8 875 14 HA1D0BWP7T $T=128800 292880 0 180 $X=120110 $Y=288670
X2451 933 906 944 8 904 14 HA1D0BWP7T $T=138880 316400 0 180 $X=130190 $Y=312190
X2452 939 665 915 8 899 14 HA1D0BWP7T $T=140000 238000 1 180 $X=131310 $Y=237765
X2453 958 594 964 8 932 14 HA1D0BWP7T $T=144480 245840 1 180 $X=135790 $Y=245605
X2454 967 936 951 8 935 14 HA1D0BWP7T $T=145600 347760 0 180 $X=136910 $Y=343550
X2455 924 949 937 8 956 14 HA1D0BWP7T $T=137760 269360 1 0 $X=137470 $Y=265150
X2456 994 985 993 8 969 14 HA1D0BWP7T $T=152880 308560 0 180 $X=144190 $Y=304350
X2457 1002 986 1009 8 962 14 HA1D0BWP7T $T=155120 332080 1 180 $X=146430 $Y=331845
X2458 999 997 1000 8 979 14 HA1D0BWP7T $T=155680 269360 1 180 $X=146990 $Y=269125
X2459 988 980 974 8 1012 14 HA1D0BWP7T $T=147840 363440 1 0 $X=147550 $Y=359230
X2460 1058 1054 994 8 1020 14 HA1D0BWP7T $T=166320 308560 1 180 $X=157630 $Y=308325
X2461 991 1023 1026 8 1056 14 HA1D0BWP7T $T=159040 339920 1 0 $X=158750 $Y=335710
X2462 1017 1048 1073 8 1029 14 HA1D0BWP7T $T=167440 347760 1 180 $X=158750 $Y=347525
X2463 1082 771 1058 8 1122 14 HA1D0BWP7T $T=166880 308560 0 0 $X=166590 $Y=308325
X2464 1083 1099 1086 8 1131 14 HA1D0BWP7T $T=169680 332080 0 0 $X=169390 $Y=331845
X2465 1136 772 1126 8 1173 14 HA1D0BWP7T $T=176400 355600 0 0 $X=176110 $Y=355365
X2466 1126 1139 1127 8 1174 14 HA1D0BWP7T $T=176400 371280 1 0 $X=176110 $Y=367070
X2467 1127 1135 1085 8 1171 14 HA1D0BWP7T $T=176400 371280 0 0 $X=176110 $Y=371045
X2468 1255 583 1254 8 1206 14 HA1D0BWP7T $T=203280 379120 1 180 $X=194590 $Y=378885
X2469 1262 1243 1266 8 1237 14 HA1D0BWP7T $T=205520 363440 1 180 $X=196830 $Y=363205
X2470 1257 1252 1241 8 1284 14 HA1D0BWP7T $T=201040 386960 0 0 $X=200750 $Y=386725
X2471 1293 1292 1283 8 1264 14 HA1D0BWP7T $T=212800 355600 1 180 $X=204110 $Y=355365
X2472 1356 1318 1325 8 1322 14 HA1D0BWP7T $T=224000 285040 0 180 $X=215310 $Y=280830
X2473 1337 645 1332 8 1380 14 HA1D0BWP7T $T=216720 386960 0 0 $X=216430 $Y=386725
X2474 1345 1309 1327 8 1377 14 HA1D0BWP7T $T=217280 324240 1 0 $X=216990 $Y=320030
X2475 1359 408 1346 8 1394 14 HA1D0BWP7T $T=220080 238000 0 0 $X=219790 $Y=237765
X2476 1381 1316 1361 8 1413 14 HA1D0BWP7T $T=222880 371280 0 0 $X=222590 $Y=371045
X2477 1407 1365 1371 8 1352 14 HA1D0BWP7T $T=231840 261520 1 180 $X=223150 $Y=261285
X2478 1358 589 1429 8 1378 14 HA1D0BWP7T $T=233520 379120 1 180 $X=224830 $Y=378885
X2479 1399 1390 1345 8 1417 14 HA1D0BWP7T $T=225680 324240 1 0 $X=225390 $Y=320030
X2480 1395 1306 1385 8 1428 14 HA1D0BWP7T $T=226240 269360 1 0 $X=225950 $Y=265150
X2481 1396 1298 1372 8 1423 14 HA1D0BWP7T $T=226240 300720 1 0 $X=225950 $Y=296510
X2482 1401 1317 1389 8 1430 14 HA1D0BWP7T $T=226800 285040 1 0 $X=226510 $Y=280830
X2483 1361 670 1391 8 1449 14 HA1D0BWP7T $T=227360 371280 1 0 $X=227070 $Y=367070
X2484 1386 1351 1420 8 1466 14 HA1D0BWP7T $T=232400 277200 1 0 $X=232110 $Y=272990
X2485 1376 597 1427 8 1493 14 HA1D0BWP7T $T=241920 245840 0 0 $X=241630 $Y=245605
X2486 1516 636 1521 8 1468 14 HA1D0BWP7T $T=250320 253680 0 180 $X=241630 $Y=249470
X2487 1478 775 1459 8 1532 14 HA1D0BWP7T $T=241920 324240 0 0 $X=241630 $Y=324005
X2488 1391 585 1462 8 1547 14 HA1D0BWP7T $T=241920 371280 0 0 $X=241630 $Y=371045
X2489 1503 776 1483 8 1536 14 HA1D0BWP7T $T=244160 308560 1 0 $X=243870 $Y=304350
X2490 1498 1499 1560 8 1472 14 HA1D0BWP7T $T=255360 324240 0 180 $X=246670 $Y=320030
X2491 1587 1312 1613 8 1563 14 HA1D0BWP7T $T=264320 230160 1 180 $X=255630 $Y=229925
X2492 1616 777 1588 8 1574 14 HA1D0BWP7T $T=267120 347760 0 180 $X=258430 $Y=343550
X2493 1521 677 1587 8 1643 14 HA1D0BWP7T $T=259840 245840 1 0 $X=259550 $Y=241630
X2494 77 1573 1656 8 1590 14 HA1D0BWP7T $T=268800 379120 0 180 $X=260110 $Y=374910
X2495 1664 424 1647 8 1695 14 HA1D0BWP7T $T=269920 261520 1 0 $X=269630 $Y=257310
X2496 1578 1621 1627 8 1697 14 HA1D0BWP7T $T=269920 308560 0 0 $X=269630 $Y=308325
X2497 428 1716 1743 8 425 14 HA1D0BWP7T $T=283920 175280 0 180 $X=275230 $Y=171070
X2498 1733 1730 1686 8 1734 14 HA1D0BWP7T $T=280560 316400 1 0 $X=280270 $Y=312190
X2499 1632 1619 1708 8 1770 14 HA1D0BWP7T $T=281120 355600 1 0 $X=280830 $Y=351390
X2500 1735 1604 1728 8 1763 14 HA1D0BWP7T $T=281680 379120 1 0 $X=281390 $Y=374910
X2501 1739 640 1779 8 1690 14 HA1D0BWP7T $T=294000 245840 1 180 $X=285310 $Y=245605
X2502 1749 511 1735 8 1791 14 HA1D0BWP7T $T=286160 379120 0 0 $X=285870 $Y=378885
X2503 1768 1778 1760 8 1764 14 HA1D0BWP7T $T=287840 190960 0 0 $X=287550 $Y=190725
X2504 1786 1712 1794 8 1758 14 HA1D0BWP7T $T=296240 261520 0 180 $X=287550 $Y=257310
X2505 1756 727 1761 8 1811 14 HA1D0BWP7T $T=287840 316400 0 0 $X=287550 $Y=316165
X2506 1861 1784 1847 8 1828 14 HA1D0BWP7T $T=309120 316400 1 180 $X=300430 $Y=316165
X2507 1845 1815 1848 8 1880 14 HA1D0BWP7T $T=304080 371280 1 0 $X=303790 $Y=367070
X2508 1881 1827 1876 8 1852 14 HA1D0BWP7T $T=313600 339920 0 180 $X=304910 $Y=335710
X2509 1895 1820 1881 8 1915 14 HA1D0BWP7T $T=313600 339920 0 0 $X=313310 $Y=339685
X2510 1912 1795 1923 8 1885 14 HA1D0BWP7T $T=322000 371280 1 180 $X=313310 $Y=371045
X2511 1853 729 1895 8 1948 14 HA1D0BWP7T $T=325920 339920 0 0 $X=325630 $Y=339685
X2512 1994 2005 1953 8 2003 14 HA1D0BWP7T $T=338240 332080 1 0 $X=337950 $Y=327870
X2513 2064 600 2058 8 1998 14 HA1D0BWP7T $T=352800 347760 1 180 $X=344110 $Y=347525
X2514 2033 604 2101 8 2073 14 HA1D0BWP7T $T=362880 339920 1 180 $X=354190 $Y=339685
X2515 2121 2083 2125 8 2099 14 HA1D0BWP7T $T=372400 324240 0 180 $X=363710 $Y=320030
X2516 2128 118 2126 8 2141 14 HA1D0BWP7T $T=372400 277200 1 0 $X=372110 $Y=272990
X2517 2118 2040 2143 8 2156 14 HA1D0BWP7T $T=381920 222320 1 0 $X=381630 $Y=218110
X2518 2130 2030 2146 8 2158 14 HA1D0BWP7T $T=383600 308560 0 0 $X=383310 $Y=308325
X2519 2152 2054 2148 8 2159 14 HA1D0BWP7T $T=385840 230160 0 0 $X=385550 $Y=229925
X2520 806 796 8 744 14 INR2D1BWP7T $T=98560 253680 1 180 $X=95470 $Y=253445
X2521 803 796 8 765 14 INR2D1BWP7T $T=99120 238000 1 180 $X=96030 $Y=237765
X2522 812 796 8 764 14 INR2D1BWP7T $T=105280 230160 0 180 $X=102190 $Y=225950
X2523 832 630 8 226 14 INR2D1BWP7T $T=111440 292880 1 180 $X=108350 $Y=292645
X2524 837 630 8 359 14 INR2D1BWP7T $T=112560 308560 1 180 $X=109470 $Y=308325
X2525 840 796 8 369 14 INR2D1BWP7T $T=113120 269360 0 0 $X=112830 $Y=269125
X2526 861 796 8 360 14 INR2D1BWP7T $T=118160 238000 1 180 $X=115070 $Y=237765
X2527 865 796 8 225 14 INR2D1BWP7T $T=118720 269360 1 180 $X=115630 $Y=269125
X2528 875 630 8 229 14 INR2D1BWP7T $T=120400 285040 0 0 $X=120110 $Y=284805
X2529 899 796 8 231 14 INR2D1BWP7T $T=126560 238000 1 180 $X=123470 $Y=237765
X2530 868 796 8 759 14 INR2D1BWP7T $T=124320 269360 1 0 $X=124030 $Y=265150
X2531 896 668 8 891 14 INR2D1BWP7T $T=132160 214480 0 0 $X=131870 $Y=214245
X2532 927 796 8 483 14 INR2D1BWP7T $T=134960 269360 0 180 $X=131870 $Y=265150
X2533 930 796 8 372 14 INR2D1BWP7T $T=136080 245840 1 180 $X=132990 $Y=245605
X2534 943 630 8 484 14 INR2D1BWP7T $T=139440 285040 0 0 $X=139150 $Y=284805
X2535 966 630 8 535 14 INR2D1BWP7T $T=144480 300720 1 180 $X=141390 $Y=300485
X2536 969 630 8 536 14 INR2D1BWP7T $T=145600 316400 1 0 $X=145310 $Y=312190
X2537 987 438 8 238 14 INR2D1BWP7T $T=149520 332080 0 180 $X=146430 $Y=327870
X2538 1020 630 8 486 14 INR2D1BWP7T $T=157920 324240 1 0 $X=157630 $Y=320030
X2539 1051 438 8 246 14 INR2D1BWP7T $T=162400 332080 1 0 $X=162110 $Y=327870
X2540 1172 438 8 252 14 INR2D1BWP7T $T=187600 332080 0 0 $X=187310 $Y=331845
X2541 1206 1214 8 257 14 INR2D1BWP7T $T=190960 379120 0 0 $X=190670 $Y=378885
X2542 1223 1214 8 768 14 INR2D1BWP7T $T=196000 371280 1 180 $X=192910 $Y=371045
X2543 1215 1214 8 258 14 INR2D1BWP7T $T=194320 394800 0 0 $X=194030 $Y=394565
X2544 1240 100 8 620 14 INR2D1BWP7T $T=198240 332080 1 180 $X=195150 $Y=331845
X2545 1236 1214 8 363 14 INR2D1BWP7T $T=197120 355600 1 0 $X=196830 $Y=351390
X2546 645 100 8 555 14 INR2D1BWP7T $T=198800 285040 1 0 $X=198510 $Y=280830
X2547 588 100 8 621 14 INR2D1BWP7T $T=204960 269360 1 180 $X=201870 $Y=269125
X2548 1258 100 8 471 14 INR2D1BWP7T $T=207200 316400 1 180 $X=204110 $Y=316165
X2549 1264 1214 8 268 14 INR2D1BWP7T $T=205520 363440 0 0 $X=205230 $Y=363205
X2550 1302 100 8 256 14 INR2D1BWP7T $T=211120 285040 1 180 $X=208030 $Y=284805
X2551 1326 631 8 541 14 INR2D1BWP7T $T=216720 300720 0 180 $X=213630 $Y=296510
X2552 589 100 8 264 14 INR2D1BWP7T $T=218400 339920 1 180 $X=215310 $Y=339685
X2553 1305 1214 8 269 14 INR2D1BWP7T $T=215600 355600 1 0 $X=215310 $Y=351390
X2554 1336 796 8 489 14 INR2D1BWP7T $T=218960 238000 1 180 $X=215870 $Y=237765
X2555 1322 631 8 540 14 INR2D1BWP7T $T=219520 285040 1 180 $X=216430 $Y=284805
X2556 669 100 8 253 14 INR2D1BWP7T $T=221200 339920 1 180 $X=218110 $Y=339685
X2557 1354 631 8 272 14 INR2D1BWP7T $T=221760 332080 1 0 $X=221470 $Y=327870
X2558 1380 1214 8 459 14 INR2D1BWP7T $T=227360 402640 1 0 $X=227070 $Y=398430
X2559 1423 631 8 274 14 INR2D1BWP7T $T=232960 300720 0 0 $X=232670 $Y=300485
X2560 1428 631 8 278 14 INR2D1BWP7T $T=234640 261520 0 0 $X=234350 $Y=261285
X2561 1448 796 8 479 14 INR2D1BWP7T $T=237440 245840 1 0 $X=237150 $Y=241630
X2562 1444 631 8 461 14 INR2D1BWP7T $T=238000 277200 0 0 $X=237710 $Y=276965
X2563 1466 631 8 281 14 INR2D1BWP7T $T=243040 277200 1 0 $X=242750 $Y=272990
X2564 1472 631 8 462 14 INR2D1BWP7T $T=243040 332080 1 0 $X=242750 $Y=327870
X2565 1494 1214 8 387 14 INR2D1BWP7T $T=246400 379120 0 0 $X=246110 $Y=378885
X2566 512 414 8 84 14 INR2D1BWP7T $T=252560 112560 1 180 $X=249470 $Y=112325
X2567 1547 1214 8 280 14 INR2D1BWP7T $T=253120 371280 1 0 $X=252830 $Y=367070
X2568 1514 1214 8 289 14 INR2D1BWP7T $T=254240 363440 0 0 $X=253950 $Y=363205
X2569 1584 796 8 295 14 INR2D1BWP7T $T=258160 238000 1 0 $X=257870 $Y=233790
X2570 597 100 8 294 14 INR2D1BWP7T $T=259840 230160 1 0 $X=259550 $Y=225950
X2571 76 100 8 377 14 INR2D1BWP7T $T=260960 285040 1 0 $X=260670 $Y=280830
X2572 1643 1214 8 560 14 INR2D1BWP7T $T=267680 253680 1 180 $X=264590 $Y=253445
X2573 1659 631 8 492 14 INR2D1BWP7T $T=272720 316400 1 180 $X=269630 $Y=316165
X2574 1662 1629 8 1651 14 INR2D1BWP7T $T=273280 96880 1 180 $X=270190 $Y=96645
X2575 1677 1214 8 495 14 INR2D1BWP7T $T=274960 355600 1 180 $X=271870 $Y=355365
X2576 1668 796 8 305 14 INR2D1BWP7T $T=273280 245840 1 0 $X=272990 $Y=241630
X2577 1690 796 8 303 14 INR2D1BWP7T $T=277200 253680 0 180 $X=274110 $Y=249470
X2578 1502 100 8 493 14 INR2D1BWP7T $T=274960 332080 0 0 $X=274670 $Y=331845
X2579 1734 631 8 304 14 INR2D1BWP7T $T=283920 324240 1 180 $X=280830 $Y=324005
X2580 1604 100 8 306 14 INR2D1BWP7T $T=283920 339920 0 180 $X=280830 $Y=335710
X2581 1704 100 8 763 14 INR2D1BWP7T $T=292320 347760 0 180 $X=289230 $Y=343550
X2582 1652 1214 8 299 14 INR2D1BWP7T $T=292320 277200 1 0 $X=292030 $Y=272990
X2583 1789 631 8 532 14 INR2D1BWP7T $T=293440 324240 1 0 $X=293150 $Y=320030
X2584 1312 100 8 309 14 INR2D1BWP7T $T=300720 230160 1 180 $X=297630 $Y=229925
X2585 1826 1214 8 318 14 INR2D1BWP7T $T=300720 363440 0 180 $X=297630 $Y=359230
X2586 636 100 8 312 14 INR2D1BWP7T $T=301280 230160 0 180 $X=298190 $Y=225950
X2587 1828 630 8 449 14 INR2D1BWP7T $T=303520 324240 1 0 $X=303230 $Y=320030
X2588 1880 1214 8 317 14 INR2D1BWP7T $T=311920 363440 1 0 $X=311630 $Y=359230
X2589 1885 1214 8 390 14 INR2D1BWP7T $T=315280 371280 0 180 $X=312190 $Y=367070
X2590 1948 438 8 325 14 INR2D1BWP7T $T=330400 339920 0 180 $X=327310 $Y=335710
X2591 2017 1214 8 329 14 INR2D1BWP7T $T=338240 363440 1 180 $X=335150 $Y=363205
X2592 519 2022 8 440 14 INR2D1BWP7T $T=351680 136080 1 180 $X=348590 $Y=135845
X2593 2055 2018 8 116 14 INR2D1BWP7T $T=351680 206640 0 180 $X=348590 $Y=202430
X2594 2141 631 8 351 14 INR2D1BWP7T $T=383040 277200 1 0 $X=382750 $Y=272990
X2595 2155 631 8 498 14 INR2D1BWP7T $T=388080 300720 0 180 $X=384990 $Y=296510
X2596 2158 631 8 499 14 INR2D1BWP7T $T=388080 316400 0 180 $X=384990 $Y=312190
X2597 2153 631 8 353 14 INR2D1BWP7T $T=388080 332080 1 180 $X=384990 $Y=331845
X2598 829 593 8 812 14 CKXOR2D1BWP7T $T=110880 230160 0 180 $X=105550 $Y=225950
X2599 820 399 8 861 14 CKXOR2D1BWP7T $T=113120 245840 1 0 $X=112830 $Y=241630
X2600 858 845 8 832 14 CKXOR2D1BWP7T $T=118160 292880 1 180 $X=112830 $Y=292645
X2601 842 581 8 865 14 CKXOR2D1BWP7T $T=114240 261520 0 0 $X=113950 $Y=261285
X2602 905 584 8 927 14 CKXOR2D1BWP7T $T=130480 261520 0 0 $X=130190 $Y=261285
X2603 915 592 8 930 14 CKXOR2D1BWP7T $T=132160 245840 1 0 $X=131870 $Y=241630
X2604 908 911 8 943 14 CKXOR2D1BWP7T $T=136080 292880 1 0 $X=135790 $Y=288670
X2605 937 948 8 955 14 CKXOR2D1BWP7T $T=137760 261520 0 0 $X=137470 $Y=261285
X2606 951 941 8 923 14 CKXOR2D1BWP7T $T=142800 339920 1 180 $X=137470 $Y=339685
X2607 974 938 8 952 14 CKXOR2D1BWP7T $T=146720 363440 1 180 $X=141390 $Y=363205
X2608 993 981 8 966 14 CKXOR2D1BWP7T $T=151200 300720 1 180 $X=145870 $Y=300485
X2609 1000 975 8 977 14 CKXOR2D1BWP7T $T=154000 277200 1 180 $X=148670 $Y=276965
X2610 1009 970 8 987 14 CKXOR2D1BWP7T $T=155680 332080 0 180 $X=150350 $Y=327870
X2611 1026 1040 8 1051 14 CKXOR2D1BWP7T $T=158480 324240 0 0 $X=158190 $Y=324005
X2612 1085 1103 8 1110 14 CKXOR2D1BWP7T $T=168560 371280 0 0 $X=168270 $Y=371045
X2613 1241 588 8 1215 14 CKXOR2D1BWP7T $T=198800 386960 1 180 $X=193470 $Y=386725
X2614 1254 582 8 1223 14 CKXOR2D1BWP7T $T=202720 371280 1 180 $X=197390 $Y=371045
X2615 1266 590 8 1236 14 CKXOR2D1BWP7T $T=205520 355600 0 180 $X=200190 $Y=351390
X2616 1325 1329 8 1347 14 CKXOR2D1BWP7T $T=215600 277200 0 0 $X=215310 $Y=276965
X2617 1332 1258 8 1383 14 CKXOR2D1BWP7T $T=217280 410480 1 0 $X=216990 $Y=406270
X2618 1372 1301 8 1326 14 CKXOR2D1BWP7T $T=225680 300720 0 180 $X=220350 $Y=296510
X2619 1346 410 8 1336 14 CKXOR2D1BWP7T $T=226240 238000 0 180 $X=220910 $Y=233790
X2620 1371 1353 8 1388 14 CKXOR2D1BWP7T $T=224000 253680 1 0 $X=223710 $Y=249470
X2621 1420 1328 8 1444 14 CKXOR2D1BWP7T $T=232400 277200 0 0 $X=232110 $Y=276965
X2622 1427 596 8 1448 14 CKXOR2D1BWP7T $T=233520 245840 0 0 $X=233230 $Y=245605
X2623 1385 1311 8 1460 14 CKXOR2D1BWP7T $T=235200 269360 1 0 $X=234910 $Y=265150
X2624 1459 1442 8 1437 14 CKXOR2D1BWP7T $T=240800 324240 0 180 $X=235470 $Y=320030
X2625 1483 1458 8 1515 14 CKXOR2D1BWP7T $T=244160 308560 0 0 $X=243870 $Y=308325
X2626 1462 669 8 1514 14 CKXOR2D1BWP7T $T=244160 363440 1 0 $X=243870 $Y=359230
X2627 1522 74 8 1494 14 CKXOR2D1BWP7T $T=250880 386960 0 180 $X=245550 $Y=382750
X2628 1588 1484 8 1556 14 CKXOR2D1BWP7T $T=260960 355600 0 180 $X=255630 $Y=351390
X2629 1560 1526 8 1597 14 CKXOR2D1BWP7T $T=257600 324240 0 0 $X=257310 $Y=324005
X2630 1613 419 8 1584 14 CKXOR2D1BWP7T $T=266000 238000 0 180 $X=260670 $Y=233790
X2631 1627 1606 8 1593 14 CKXOR2D1BWP7T $T=267680 308560 1 180 $X=262350 $Y=308325
X2632 1647 422 8 1652 14 CKXOR2D1BWP7T $T=276080 269360 1 180 $X=270750 $Y=269125
X2633 1656 1579 8 1682 14 CKXOR2D1BWP7T $T=271600 371280 0 0 $X=271310 $Y=371045
X2634 1686 1666 8 1659 14 CKXOR2D1BWP7T $T=277200 316400 0 180 $X=271870 $Y=312190
X2635 1708 1648 8 1672 14 CKXOR2D1BWP7T $T=280560 347760 1 180 $X=275230 $Y=347525
X2636 1721 1502 8 1677 14 CKXOR2D1BWP7T $T=281680 355600 1 180 $X=276350 $Y=355365
X2637 1673 1638 8 1762 14 CKXOR2D1BWP7T $T=283360 89040 1 0 $X=283070 $Y=84830
X2638 1779 432 8 1668 14 CKXOR2D1BWP7T $T=292320 245840 0 180 $X=286990 $Y=241630
X2639 1794 688 8 1766 14 CKXOR2D1BWP7T $T=295120 269360 0 180 $X=289790 $Y=265150
X2640 1814 1781 8 1821 14 CKXOR2D1BWP7T $T=304640 89040 0 180 $X=299310 $Y=84830
X2641 1847 1803 8 1824 14 CKXOR2D1BWP7T $T=305200 316400 0 180 $X=299870 $Y=312190
X2642 1848 732 8 1826 14 CKXOR2D1BWP7T $T=306320 363440 1 180 $X=300990 $Y=363205
X2643 1876 1700 8 1859 14 CKXOR2D1BWP7T $T=312480 339920 1 180 $X=307150 $Y=339685
X2644 1923 1808 8 1889 14 CKXOR2D1BWP7T $T=322560 379120 0 180 $X=317230 $Y=374910
X2645 1953 1960 8 1970 14 CKXOR2D1BWP7T $T=330400 339920 1 0 $X=330110 $Y=335710
X2646 1965 1553 8 1975 14 CKXOR2D1BWP7T $T=340480 379120 1 180 $X=335150 $Y=378885
X2647 2058 599 8 2023 14 CKXOR2D1BWP7T $T=351680 355600 0 180 $X=346350 $Y=351390
X2648 503 2107 8 502 14 CKXOR2D1BWP7T $T=362320 190960 1 0 $X=362030 $Y=186750
X2649 501 2105 8 132 14 CKXOR2D1BWP7T $T=363440 175280 1 0 $X=363150 $Y=171070
X2650 2101 602 8 2106 14 CKXOR2D1BWP7T $T=370160 339920 1 180 $X=364830 $Y=339685
X2651 2117 1984 8 2100 14 CKXOR2D1BWP7T $T=370720 214480 0 180 $X=365390 $Y=210270
X2652 2143 2006 8 2149 14 CKXOR2D1BWP7T $T=381920 214480 0 0 $X=381630 $Y=214245
X2653 2125 2079 8 2153 14 CKXOR2D1BWP7T $T=383040 324240 0 0 $X=382750 $Y=324005
X2654 2146 2046 8 2155 14 CKXOR2D1BWP7T $T=383600 308560 1 0 $X=383310 $Y=304350
X2655 14 8 792 793 795 ICV_70 $T=85120 253680 1 0 $X=84830 $Y=249470
X2656 14 8 823 398 840 ICV_70 $T=105840 269360 1 0 $X=105550 $Y=265150
X2657 14 8 852 863 869 ICV_70 $T=113120 324240 0 0 $X=112830 $Y=324005
X2658 14 8 944 925 912 ICV_70 $T=138880 316400 1 0 $X=138590 $Y=312190
X2659 14 8 1073 1028 1118 ICV_70 $T=167440 347760 0 0 $X=167150 $Y=347525
X2660 14 8 1086 1167 1172 ICV_70 $T=178080 332080 0 0 $X=177790 $Y=331845
X2661 14 8 1283 1302 1305 ICV_70 $T=205520 355600 1 0 $X=205230 $Y=351390
X2662 14 8 1327 1334 1354 ICV_70 $T=213920 324240 0 0 $X=213630 $Y=324005
X2663 14 8 1389 1282 1438 ICV_70 $T=229600 292880 0 0 $X=229310 $Y=292645
X2664 14 8 1429 1240 1454 ICV_70 $T=233520 379120 0 0 $X=233230 $Y=378885
X2665 14 8 2126 2071 2138 ICV_70 $T=372960 269360 0 0 $X=372670 $Y=269125
X2666 14 8 2148 2036 2161 ICV_70 $T=385280 222320 0 0 $X=384990 $Y=222085
X2667 799 797 8 804 14 NR2D1BWP7T $T=96320 190960 0 0 $X=96030 $Y=190725
X2668 815 826 8 817 14 NR2D1BWP7T $T=105280 159600 0 0 $X=104990 $Y=159365
X2669 395 818 8 831 14 NR2D1BWP7T $T=112560 175280 0 180 $X=110030 $Y=171070
X2670 849 44 8 24 14 NR2D1BWP7T $T=114800 175280 0 0 $X=114510 $Y=175045
X2671 866 44 8 397 14 NR2D1BWP7T $T=118720 151760 0 0 $X=118430 $Y=151525
X2672 888 32 8 880 14 NR2D1BWP7T $T=124880 253680 1 180 $X=122350 $Y=253445
X2673 889 44 8 881 14 NR2D1BWP7T $T=123760 159600 1 0 $X=123470 $Y=155390
X2674 918 402 8 833 14 NR2D1BWP7T $T=133280 151760 0 0 $X=132990 $Y=151525
X2675 1344 183 8 1358 14 NR2D1BWP7T $T=221760 379120 0 0 $X=221470 $Y=378885
X2676 1450 1475 8 1457 14 NR2D1BWP7T $T=241920 159600 1 0 $X=241630 $Y=155390
X2677 1492 1271 8 1480 14 NR2D1BWP7T $T=245840 230160 0 180 $X=243310 $Y=225950
X2678 1405 730 8 1552 14 NR2D1BWP7T $T=255920 175280 0 180 $X=253390 $Y=171070
X2679 1490 1497 8 1569 14 NR2D1BWP7T $T=255360 159600 1 0 $X=255070 $Y=155390
X2680 1582 635 8 1591 14 NR2D1BWP7T $T=258160 190960 1 0 $X=257870 $Y=186750
X2681 1611 1622 8 1610 14 NR2D1BWP7T $T=264320 183120 0 0 $X=264030 $Y=182885
X2682 1649 423 8 1516 14 NR2D1BWP7T $T=270480 253680 1 0 $X=270190 $Y=249470
X2683 1732 758 8 426 14 NR2D1BWP7T $T=283360 175280 0 0 $X=283070 $Y=175045
X2684 1799 429 8 1786 14 NR2D1BWP7T $T=294560 253680 0 180 $X=292030 $Y=249470
X2685 1817 436 8 1749 14 NR2D1BWP7T $T=300160 371280 1 0 $X=299870 $Y=367070
X2686 1944 439 8 1912 14 NR2D1BWP7T $T=329840 371280 0 180 $X=327310 $Y=367070
X2687 99 2019 8 102 14 NR2D1BWP7T $T=346080 151760 0 180 $X=343550 $Y=147550
X2688 108 2000 8 614 14 NR2D1BWP7T $T=346080 206640 0 180 $X=343550 $Y=202430
X2689 616 1962 8 598 14 NR2D1BWP7T $T=344400 190960 0 0 $X=344110 $Y=190725
X2690 2018 2035 8 1999 14 NR2D1BWP7T $T=345520 206640 0 0 $X=345230 $Y=206405
X2691 2029 441 8 2033 14 NR2D1BWP7T $T=345520 339920 0 0 $X=345230 $Y=339685
X2692 109 2019 8 2055 14 NR2D1BWP7T $T=349440 167440 1 0 $X=349150 $Y=163230
X2693 100 286 8 2052 14 NR2D1BWP7T $T=351680 269360 1 180 $X=349150 $Y=269125
X2694 2018 2027 8 526 14 NR2D1BWP7T $T=350560 206640 0 0 $X=350270 $Y=206405
X2695 2042 2053 8 2087 14 NR2D1BWP7T $T=358400 198800 0 0 $X=358110 $Y=198565
X2696 2124 444 8 2121 14 NR2D1BWP7T $T=373520 285040 0 0 $X=373230 $Y=284805
X2697 2144 445 8 2118 14 NR2D1BWP7T $T=382480 230160 1 0 $X=382190 $Y=225950
X2698 2062 631 8 497 14 NR2D1BWP7T $T=384720 292880 1 0 $X=384430 $Y=288670
X2699 427 1719 429 8 1702 14 OA21D0BWP7T $T=282240 238000 1 180 $X=278590 $Y=237765
X2700 1422 1928 439 8 1921 14 OA21D0BWP7T $T=324800 355600 1 180 $X=321150 $Y=355365
X2701 2078 2050 441 8 2086 14 OA21D0BWP7T $T=356160 332080 1 0 $X=355870 $Y=327870
X2702 1837 bit_error 196 8 339 14 OA21D0BWP7T $T=356720 238000 0 0 $X=356430 $Y=237765
X2703 1841 bit_error 196 8 342 14 OA21D0BWP7T $T=368480 285040 1 0 $X=368190 $Y=280830
X2704 2132 2062 444 8 2145 14 OA21D0BWP7T $T=376880 292880 1 0 $X=376590 $Y=288670
X2705 2024 2065 445 8 2154 14 OA21D0BWP7T $T=384720 245840 1 0 $X=384430 $Y=241630
X2706 892 887 8 862 14 AN2D1BWP7T $T=124880 143920 1 180 $X=121790 $Y=143685
X2707 962 286 8 760 14 AN2D1BWP7T $T=143920 332080 1 180 $X=140830 $Y=331845
X2708 935 286 8 233 14 AN2D1BWP7T $T=141120 347760 0 0 $X=140830 $Y=347525
X2709 952 286 8 618 14 AN2D1BWP7T $T=142240 363440 1 0 $X=141950 $Y=359230
X2710 1029 286 8 243 14 AN2D1BWP7T $T=159040 355600 0 0 $X=158750 $Y=355365
X2711 1012 286 8 244 14 AN2D1BWP7T $T=160160 363440 1 0 $X=159870 $Y=359230
X2712 1110 286 8 767 14 AN2D1BWP7T $T=173600 371280 0 180 $X=170510 $Y=367070
X2713 1118 286 8 475 14 AN2D1BWP7T $T=175280 355600 0 180 $X=172190 $Y=351390
X2714 1171 286 8 538 14 AN2D1BWP7T $T=176960 379120 0 180 $X=173870 $Y=374910
X2715 1173 286 8 487 14 AN2D1BWP7T $T=187040 355600 0 0 $X=186750 $Y=355365
X2716 1174 286 8 254 14 AN2D1BWP7T $T=187040 371280 1 0 $X=186750 $Y=367070
X2717 196 1243 8 251 14 AN2D1BWP7T $T=199920 324240 1 180 $X=196830 $Y=324005
X2718 196 582 8 556 14 AN2D1BWP7T $T=199360 269360 0 0 $X=199070 $Y=269125
X2719 196 1252 8 455 14 AN2D1BWP7T $T=200480 332080 1 0 $X=200190 $Y=327870
X2720 196 583 8 456 14 AN2D1BWP7T $T=201600 253680 0 0 $X=201310 $Y=253445
X2721 196 1292 8 259 14 AN2D1BWP7T $T=211680 316400 1 180 $X=208590 $Y=316165
X2722 196 590 8 457 14 AN2D1BWP7T $T=211680 324240 0 180 $X=208590 $Y=320030
X2723 196 1316 8 263 14 AN2D1BWP7T $T=217840 332080 0 180 $X=214750 $Y=327870
X2724 1556 286 8 285 14 AN2D1BWP7T $T=254800 347760 0 180 $X=251710 $Y=343550
X2725 1525 1565 8 523 14 AN2D1BWP7T $T=254800 183120 0 0 $X=254510 $Y=182885
X2726 1574 286 8 288 14 AN2D1BWP7T $T=257600 347760 0 180 $X=254510 $Y=343550
X2727 1672 286 8 494 14 AN2D1BWP7T $T=274400 347760 1 180 $X=271310 $Y=347525
X2728 1770 286 8 531 14 AN2D1BWP7T $T=290640 355600 1 0 $X=290350 $Y=351390
X2729 435 283 8 1754 14 AN2D1BWP7T $T=301840 269360 1 180 $X=298750 $Y=269125
X2730 1852 286 8 465 14 AN2D1BWP7T $T=306880 347760 1 0 $X=306590 $Y=343550
X2731 1859 286 8 450 14 AN2D1BWP7T $T=307440 332080 1 0 $X=307150 $Y=327870
X2732 1915 286 8 473 14 AN2D1BWP7T $T=321440 347760 1 180 $X=318350 $Y=347525
X2733 1998 286 8 366 14 AN2D1BWP7T $T=341040 347760 1 180 $X=337950 $Y=347525
X2734 2023 286 8 552 14 AN2D1BWP7T $T=344960 355600 0 180 $X=341870 $Y=351390
X2735 697 cfg_re_dbg 8 2026 14 AN2D1BWP7T $T=347760 136080 0 180 $X=344670 $Y=131870
X2736 790 196 8 332 14 AN2D1BWP7T $T=344960 214480 0 0 $X=344670 $Y=214245
X2737 2026 2032 8 442 14 AN2D1BWP7T $T=347760 159600 0 0 $X=347470 $Y=159365
X2738 442 440 8 610 14 AN2D1BWP7T $T=351120 167440 1 180 $X=348030 $Y=167205
X2739 438 119 8 2090 14 AN2D1BWP7T $T=355600 261520 0 0 $X=355310 $Y=261285
X2740 123 574 8 2112 14 AN2D1BWP7T $T=364000 198800 0 0 $X=363710 $Y=198565
X2741 123 mode_select_dbg 8 2127 14 AN2D1BWP7T $T=366800 198800 0 0 $X=366510 $Y=198565
X2742 checker_in 196 8 347 14 AN2D1BWP7T $T=380800 253680 0 180 $X=377710 $Y=249470
X2743 prbs_out 196 8 451 14 AN2D1BWP7T $T=385840 238000 0 180 $X=382750 $Y=233790
X2744 checker_in_final 196 8 481 14 AN2D1BWP7T $T=386400 253680 0 180 $X=383310 $Y=249470
X2745 801 798 8 505 14 ND2D1BWP7T $T=98560 214480 0 180 $X=96030 $Y=210270
X2746 817 168 8 575 14 ND2D1BWP7T $T=106400 167440 0 180 $X=103870 $Y=163230
X2747 828 168 8 819 14 ND2D1BWP7T $T=110880 167440 0 180 $X=108350 $Y=163230
X2748 831 833 8 838 14 ND2D1BWP7T $T=111440 167440 0 0 $X=111150 $Y=167205
X2749 398 587 8 33 14 ND2D1BWP7T $T=114800 261520 0 180 $X=112270 $Y=257310
X2750 733 843 8 844 14 ND2D1BWP7T $T=117040 183120 1 180 $X=114510 $Y=182885
X2751 664 399 8 34 14 ND2D1BWP7T $T=117040 253680 0 180 $X=114510 $Y=249470
X2752 862 396 8 866 14 ND2D1BWP7T $T=118160 151760 1 0 $X=117870 $Y=147550
X2753 396 168 8 40 14 ND2D1BWP7T $T=122640 175280 0 0 $X=122350 $Y=175045
X2754 892 396 8 889 14 ND2D1BWP7T $T=125440 151760 0 180 $X=122910 $Y=147550
X2755 873 895 8 578 14 ND2D1BWP7T $T=123200 222320 1 0 $X=122910 $Y=218110
X2756 898 168 8 901 14 ND2D1BWP7T $T=126000 190960 0 0 $X=125710 $Y=190725
X2757 913 909 8 910 14 ND2D1BWP7T $T=132720 183120 1 180 $X=130190 $Y=182885
X2758 893 911 8 885 14 ND2D1BWP7T $T=133280 292880 0 180 $X=130750 $Y=288670
X2759 907 887 8 918 14 ND2D1BWP7T $T=132160 159600 0 0 $X=131870 $Y=159365
X2760 872 845 8 914 14 ND2D1BWP7T $T=133280 292880 0 0 $X=132990 $Y=292645
X2761 940 921 8 633 14 ND2D1BWP7T $T=136080 222320 1 180 $X=133550 $Y=222085
X2762 909 168 8 926 14 ND2D1BWP7T $T=136640 190960 1 180 $X=134110 $Y=190725
X2763 906 925 8 929 14 ND2D1BWP7T $T=136640 308560 1 180 $X=134110 $Y=308325
X2764 980 938 8 982 14 ND2D1BWP7T $T=150640 347760 1 0 $X=150350 $Y=343550
X2765 1048 1028 8 995 14 ND2D1BWP7T $T=161280 339920 1 180 $X=158750 $Y=339685
X2766 1062 1082 8 400 14 ND2D1BWP7T $T=167440 300720 0 0 $X=167150 $Y=300485
X2767 1152 1136 8 407 14 ND2D1BWP7T $T=180320 355600 0 180 $X=177790 $Y=351390
X2768 583 582 8 1265 14 ND2D1BWP7T $T=208880 371280 1 180 $X=206350 $Y=371045
X2769 394 593 8 1324 14 ND2D1BWP7T $T=215040 222320 0 0 $X=214750 $Y=222085
X2770 1306 1311 8 1360 14 ND2D1BWP7T $T=221760 269360 1 0 $X=221470 $Y=265150
X2771 1298 1301 8 1357 14 ND2D1BWP7T $T=229600 292880 1 180 $X=227070 $Y=292645
X2772 1412 1424 8 409 14 ND2D1BWP7T $T=230720 316400 1 0 $X=230430 $Y=312190
X2773 739 1414 8 1403 14 ND2D1BWP7T $T=233520 183120 1 180 $X=230990 $Y=182885
X2774 412 1455 8 1431 14 ND2D1BWP7T $T=237440 214480 0 0 $X=237150 $Y=214245
X2775 1457 66 8 704 14 ND2D1BWP7T $T=240240 159600 1 180 $X=237710 $Y=159365
X2776 92 522 8 412 14 ND2D1BWP7T $T=244720 222320 0 180 $X=242190 $Y=218110
X2777 512 1509 8 524 14 ND2D1BWP7T $T=251440 120400 0 180 $X=248910 $Y=116190
X2778 1520 1540 8 1530 14 ND2D1BWP7T $T=249760 167440 1 0 $X=249470 $Y=163230
X2779 741 1512 8 1525 14 ND2D1BWP7T $T=249760 183120 0 0 $X=249470 $Y=182885
X2780 1552 1540 8 1566 14 ND2D1BWP7T $T=257600 167440 1 180 $X=255070 $Y=167205
X2781 1573 1579 8 70 14 ND2D1BWP7T $T=257040 371280 0 0 $X=256750 $Y=371045
X2782 1566 1595 8 418 14 ND2D1BWP7T $T=258720 175280 0 0 $X=258430 $Y=175045
X2783 1586 1576 8 1607 14 ND2D1BWP7T $T=262640 112560 1 0 $X=262350 $Y=108350
X2784 1655 428 8 421 14 ND2D1BWP7T $T=272160 167440 0 180 $X=269630 $Y=163230
X2785 422 424 8 1649 14 ND2D1BWP7T $T=272720 245840 1 180 $X=270190 $Y=245605
X2786 1576 1653 8 1674 14 ND2D1BWP7T $T=273280 128240 0 0 $X=272990 $Y=128005
X2787 1667 1681 8 1675 14 ND2D1BWP7T $T=273280 183120 1 0 $X=272990 $Y=178910
X2788 1717 1744 8 525 14 ND2D1BWP7T $T=281680 183120 0 0 $X=281390 $Y=182885
X2789 1732 1757 8 1753 14 ND2D1BWP7T $T=285600 198800 1 0 $X=285310 $Y=194590
X2790 638 1753 8 639 14 ND2D1BWP7T $T=288960 198800 1 180 $X=286430 $Y=198565
X2791 640 432 8 1799 14 ND2D1BWP7T $T=294000 245840 0 0 $X=293710 $Y=245605
X2792 732 1815 8 1817 14 ND2D1BWP7T $T=297920 363440 0 0 $X=297630 $Y=363205
X2793 1908 1896 8 1814 14 ND2D1BWP7T $T=318080 89040 0 180 $X=315550 $Y=84830
X2794 438 435 8 520 14 ND2D1BWP7T $T=318640 269360 1 180 $X=316110 $Y=269125
X2795 1916 1912 8 436 14 ND2D1BWP7T $T=320880 371280 1 0 $X=320590 $Y=367070
X2796 1422 1928 8 439 14 ND2D1BWP7T $T=329840 355600 1 180 $X=327310 $Y=355365
X2797 518 1553 8 1944 14 ND2D1BWP7T $T=330960 363440 1 180 $X=328430 $Y=363205
X2798 1917 1983 8 1946 14 ND2D1BWP7T $T=329280 253680 1 0 $X=328990 $Y=249470
X2799 cfg_re_dbg 440 8 106 14 ND2D1BWP7T $T=338240 136080 1 0 $X=337950 $Y=131870
X2800 1959 2010 8 2008 14 ND2D1BWP7T $T=340480 300720 0 0 $X=340190 $Y=300485
X2801 2005 1960 8 2029 14 ND2D1BWP7T $T=347200 339920 0 180 $X=344670 $Y=335710
X2802 600 599 8 2043 14 ND2D1BWP7T $T=350000 339920 1 180 $X=347470 $Y=339685
X2803 2080 116 8 1902 14 ND2D1BWP7T $T=357280 238000 0 180 $X=354750 $Y=233790
X2804 2094 2076 8 prbs_out 14 ND2D1BWP7T $T=358400 190960 1 180 $X=355870 $Y=190725
X2805 2050 2078 8 441 14 ND2D1BWP7T $T=357280 324240 1 0 $X=356990 $Y=320030
X2806 604 602 8 2051 14 ND2D1BWP7T $T=360080 339920 1 0 $X=359790 $Y=335710
X2807 2102 input_select_dbg 8 2095 14 ND2D1BWP7T $T=365120 230160 0 180 $X=362590 $Y=225950
X2808 2107 574 8 2076 14 ND2D1BWP7T $T=366240 190960 1 180 $X=363710 $Y=190725
X2809 2083 2079 8 2119 14 ND2D1BWP7T $T=371840 308560 1 180 $X=369310 $Y=308325
X2810 438 bit_error 8 443 14 ND2D1BWP7T $T=369600 332080 1 0 $X=369310 $Y=327870
X2811 118 2071 8 2124 14 ND2D1BWP7T $T=370720 269360 0 0 $X=370430 $Y=269125
X2812 2030 2046 8 2133 14 ND2D1BWP7T $T=379680 308560 0 180 $X=377150 $Y=304350
X2813 2054 2036 8 2144 14 ND2D1BWP7T $T=385280 222320 1 180 $X=382750 $Y=222085
X2814 8 14 1440 TIELBWP7T $T=239120 222320 1 180 $X=237150 $Y=222085
X2815 8 14 1471 TIELBWP7T $T=244160 253680 1 180 $X=242190 $Y=253445
X2816 8 14 1549 TIELBWP7T $T=254240 261520 0 0 $X=253950 $Y=261285
X2817 8 14 1630 TIELBWP7T $T=268800 96880 1 180 $X=266830 $Y=96645
X2818 8 14 1644 TIELBWP7T $T=271600 285040 0 180 $X=269630 $Y=280830
X2819 8 14 1527 TIELBWP7T $T=272160 347760 0 180 $X=270190 $Y=343550
X2820 8 14 1689 TIELBWP7T $T=278320 214480 1 180 $X=276350 $Y=214245
X2821 8 14 1696 TIELBWP7T $T=279440 159600 1 180 $X=277470 $Y=159365
X2822 8 14 1698 TIELBWP7T $T=280000 214480 1 180 $X=278030 $Y=214245
X2823 8 14 1671 TIELBWP7T $T=281120 104720 0 180 $X=279150 $Y=100510
X2824 8 14 1713 TIELBWP7T $T=281680 300720 1 180 $X=279710 $Y=300485
X2825 8 14 1657 TIELBWP7T $T=283360 120400 1 180 $X=281390 $Y=120165
X2826 8 14 1707 TIELBWP7T $T=294560 143920 1 180 $X=292590 $Y=143685
X2827 8 14 1759 TIELBWP7T $T=294560 285040 1 180 $X=292590 $Y=284805
X2828 8 14 1705 TIELBWP7T $T=298480 128240 0 0 $X=298190 $Y=128005
X2829 8 14 1706 TIELBWP7T $T=328160 143920 0 180 $X=326190 $Y=139710
X2830 8 14 1742 TIELBWP7T $T=328160 324240 0 180 $X=326190 $Y=320030
X2831 8 14 2044 TIELBWP7T $T=344960 128240 1 0 $X=344670 $Y=124030
X2832 8 14 2047 TIELBWP7T $T=351120 151760 0 180 $X=349150 $Y=147550
X2833 8 14 2069 TIELBWP7T $T=356160 292880 0 180 $X=354190 $Y=288670
X2834 8 14 2089 TIELBWP7T $T=370160 238000 0 0 $X=369870 $Y=237765
X2835 8 14 2142 TIELBWP7T $T=384160 206640 0 180 $X=382190 $Y=202430
X2860 rst_n 8 791 14 CKBD1BWP7T $T=89600 151760 1 0 $X=89310 $Y=147550
X2861 808 8 794 14 CKBD1BWP7T $T=104160 261520 0 180 $X=101630 $Y=257310
X2862 920 8 830 14 CKBD1BWP7T $T=134400 300720 0 180 $X=131870 $Y=296510
X2863 808 8 836 14 CKBD1BWP7T $T=150080 245840 0 0 $X=149790 $Y=245605
X2864 920 8 821 14 CKBD1BWP7T $T=160160 300720 0 180 $X=157630 $Y=296510
X2865 1027 8 916 14 CKBD1BWP7T $T=160160 332080 0 180 $X=157630 $Y=327870
X2866 1055 8 968 14 CKBD1BWP7T $T=164080 151760 1 180 $X=161550 $Y=151525
X2867 1027 8 1075 14 CKBD1BWP7T $T=170800 332080 1 0 $X=170510 $Y=327870
X2868 1107 8 1022 14 CKBD1BWP7T $T=174160 151760 1 180 $X=171630 $Y=151525
X2869 1055 8 1070 14 CKBD1BWP7T $T=185920 151760 0 0 $X=185630 $Y=151525
X2870 1186 8 1024 14 CKBD1BWP7T $T=188160 269360 1 180 $X=185630 $Y=269125
X2871 1186 8 1031 14 CKBD1BWP7T $T=192080 277200 0 180 $X=189550 $Y=272990
X2872 1219 8 953 14 CKBD1BWP7T $T=196000 136080 1 180 $X=193470 $Y=135845
X2873 1219 8 1159 14 CKBD1BWP7T $T=198240 136080 0 0 $X=197950 $Y=135845
X2874 1107 8 1113 14 CKBD1BWP7T $T=199360 151760 0 0 $X=199070 $Y=151525
X2875 1299 8 1138 14 CKBD1BWP7T $T=211120 230160 0 180 $X=208590 $Y=225950
X2876 1303 8 1300 14 CKBD1BWP7T $T=212240 300720 0 180 $X=209710 $Y=296510
X2877 1303 8 1229 14 CKBD1BWP7T $T=212240 339920 0 180 $X=209710 $Y=335710
X2878 1331 8 1203 14 CKBD1BWP7T $T=217840 347760 1 180 $X=215310 $Y=347525
X2879 1299 8 1180 14 CKBD1BWP7T $T=221760 214480 0 0 $X=221470 $Y=214245
X2880 1175 8 1183 14 CKBD1BWP7T $T=226240 159600 0 0 $X=225950 $Y=159365
X2881 1281 8 1238 14 CKBD1BWP7T $T=230720 128240 1 180 $X=228190 $Y=128005
X2882 1436 8 1315 14 CKBD1BWP7T $T=236880 308560 0 180 $X=234350 $Y=304350
X2883 1307 8 1245 14 CKBD1BWP7T $T=241920 198800 0 0 $X=241630 $Y=198565
X2884 1331 8 1368 14 CKBD1BWP7T $T=244160 363440 0 180 $X=241630 $Y=359230
X2885 1299 8 1461 14 CKBD1BWP7T $T=248640 214480 0 0 $X=248350 $Y=214245
X2886 1436 8 1571 14 CKBD1BWP7T $T=255360 324240 1 0 $X=255070 $Y=320030
X2887 808 8 1313 14 CKBD1BWP7T $T=258160 245840 0 0 $X=257870 $Y=245605
X2888 1303 8 1561 14 CKBD1BWP7T $T=260400 300720 0 180 $X=257870 $Y=296510
X2889 920 8 1555 14 CKBD1BWP7T $T=260960 308560 1 0 $X=260670 $Y=304350
X2890 1307 8 1583 14 CKBD1BWP7T $T=262640 206640 0 0 $X=262350 $Y=206405
X2891 1219 8 1392 14 CKBD1BWP7T $T=268800 128240 1 180 $X=266270 $Y=128005
X2892 808 8 1641 14 CKBD1BWP7T $T=266560 245840 0 0 $X=266270 $Y=245605
X2893 1331 8 1537 14 CKBD1BWP7T $T=268800 363440 0 180 $X=266270 $Y=359230
X2894 1055 8 1384 14 CKBD1BWP7T $T=278880 151760 0 0 $X=278590 $Y=151525
X2895 1175 8 1548 14 CKBD1BWP7T $T=283360 159600 0 0 $X=283070 $Y=159365
X2896 1175 8 1783 14 CKBD1BWP7T $T=290640 159600 0 0 $X=290350 $Y=159365
X2897 1027 8 1557 14 CKBD1BWP7T $T=292880 347760 0 0 $X=292590 $Y=347525
X2898 1331 8 1834 14 CKBD1BWP7T $T=300160 355600 0 0 $X=299870 $Y=355365
X2899 1281 8 1868 14 CKBD1BWP7T $T=308000 128240 0 0 $X=307710 $Y=128005
X2900 1307 8 1878 14 CKBD1BWP7T $T=310240 206640 0 0 $X=309950 $Y=206405
X2901 1303 8 1822 14 CKBD1BWP7T $T=311360 300720 1 0 $X=311070 $Y=296510
X2902 1027 8 1927 14 CKBD1BWP7T $T=321440 347760 0 0 $X=321150 $Y=347525
X2903 1186 8 1872 14 CKBD1BWP7T $T=329840 269360 0 0 $X=329550 $Y=269125
X2904 2093 8 2072 14 CKBD1BWP7T $T=364560 159600 0 0 $X=364270 $Y=159365
X2905 920 8 2098 14 CKBD1BWP7T $T=378000 253680 0 0 $X=377710 $Y=253445
X2906 1436 8 2139 14 CKBD1BWP7T $T=384160 300720 0 180 $X=381630 $Y=296510
X2907 14 8 809 224 796 ICV_73 $T=101920 269360 1 0 $X=101630 $Y=265150
X2908 14 8 955 563 630 ICV_73 $T=142800 261520 0 0 $X=142510 $Y=261285
X2909 14 8 1388 622 631 ICV_73 $T=225680 261520 1 0 $X=225390 $Y=257310
X2910 14 8 1438 279 631 ICV_73 $T=236320 292880 0 0 $X=236030 $Y=292645
X2911 14 8 74 566 100 ICV_73 $T=236320 339920 0 0 $X=236030 $Y=339685
X2912 14 8 1460 282 631 ICV_73 $T=241920 269360 1 0 $X=241630 $Y=265150
X2913 14 8 1515 284 630 ICV_73 $T=249200 308560 0 0 $X=248910 $Y=308325
X2914 14 8 1536 290 630 ICV_73 $T=253120 308560 0 0 $X=252830 $Y=308325
X2915 14 8 1738 97 1719 ICV_73 $T=282800 222320 1 0 $X=282510 $Y=218110
X2916 14 8 2055 114 108 ICV_73 $T=353920 206640 1 0 $X=353630 $Y=202430
X2917 14 8 2145 352 631 ICV_73 $T=381920 285040 0 0 $X=381630 $Y=284805
X2918 14 8 923 562 438 ICV_74 $T=132160 332080 1 0 $X=131870 $Y=327870
X2919 14 8 956 362 630 ICV_74 $T=141120 269360 0 0 $X=140830 $Y=269125
X2920 14 8 1056 245 438 ICV_74 $T=161280 339920 0 0 $X=160990 $Y=339685
X2921 14 8 1383 276 1214 ICV_74 $T=225120 402640 0 0 $X=224830 $Y=402405
X2922 14 8 1417 558 631 ICV_74 $T=230160 324240 0 0 $X=229870 $Y=324005
X2923 14 8 1437 376 631 ICV_74 $T=234640 324240 0 0 $X=234350 $Y=324005
X2924 14 8 1430 478 631 ICV_74 $T=235200 285040 1 0 $X=234910 $Y=280830
X2925 14 8 1468 762 1214 ICV_74 $T=254800 245840 1 0 $X=254510 $Y=241630
X2926 14 8 1597 296 631 ICV_74 $T=262640 324240 0 0 $X=262350 $Y=324005
X2927 14 8 2138 350 631 ICV_74 $T=381920 269360 1 0 $X=381630 $Y=265150
X2928 232 475 14 8 1075 1028 ICV_75 $T=161840 355600 0 0 $X=161550 $Y=355365
X2929 234 476 14 8 1138 1084 ICV_75 $T=165760 214480 0 0 $X=165470 $Y=214245
X2930 232 477 14 8 1368 589 ICV_75 $T=225120 386960 0 0 $X=224830 $Y=386725
X2931 92 478 14 8 1314 1317 ICV_75 $T=225680 285040 0 0 $X=225390 $Y=284805
X2932 92 479 14 8 1313 596 ICV_75 $T=226240 238000 1 0 $X=225950 $Y=233790
X2933 139 480 14 8 94 1492 ICV_75 $T=302960 198800 0 0 $X=302670 $Y=198565
X2934 265 481 14 8 2116 117 ICV_75 $T=363440 253680 1 0 $X=363150 $Y=249470
X2935 265 196 14 8 2116 601 ICV_75 $T=366240 230160 0 0 $X=365950 $Y=229925
X2936 265 482 14 8 2098 2065 ICV_75 $T=381920 253680 0 0 $X=381630 $Y=253445
X2937 14 8 841 839 844 ICV_76 $T=114240 183120 1 0 $X=113950 $Y=178910
X2938 14 8 931 942 168 ICV_76 $T=136640 190960 0 0 $X=136350 $Y=190725
X2939 14 8 936 961 941 ICV_76 $T=141120 339920 1 0 $X=140830 $Y=335710
X2940 14 8 1569 783 1552 ICV_76 $T=256480 167440 1 0 $X=256190 $Y=163230
X2941 14 8 busy 641 614 ICV_76 $T=315280 245840 1 0 $X=314990 $Y=241630
X2942 14 8 99 109 cfg_re_dbg ICV_76 $T=345520 143920 0 0 $X=345230 $Y=143685
X2943 14 8 2105 2094 527 ICV_76 $T=361200 183120 1 0 $X=360910 $Y=178910
X2944 14 8 2002 2115 1984 ICV_76 $T=365120 214480 0 0 $X=364830 $Y=214245
X2945 14 8 2040 2113 2006 ICV_76 $T=367920 222320 1 0 $X=367630 $Y=218110
X2946 14 8 2062 444 2132 ICV_76 $T=375760 285040 0 0 $X=375470 $Y=284805
X2947 14 8 2065 445 2024 ICV_76 $T=381920 238000 0 0 $X=381630 $Y=237765
X2948 14 8 591 810 807 ICV_77 $T=101920 222320 1 0 $X=101630 $Y=218110
X2949 14 8 592 385 98 ICV_77 $T=179760 222320 1 0 $X=179470 $Y=218110
X2950 14 8 665 247 98 ICV_77 $T=179760 238000 0 0 $X=179470 $Y=237765
X2951 14 8 664 488 98 ICV_77 $T=213920 190960 1 0 $X=213630 $Y=186750
X2952 14 8 1552 1520 1497 ICV_77 $T=252000 167440 1 0 $X=251710 $Y=163230
X2953 14 8 1702 544 796 ICV_77 $T=274960 238000 1 0 $X=274670 $Y=233790
X2954 14 8 1910 464 630 ICV_77 $T=309680 308560 0 0 $X=309390 $Y=308325
X2955 14 8 427 328 100 ICV_77 $T=329840 238000 1 0 $X=329550 $Y=233790
X2956 14 8 518 383 100 ICV_77 $T=330960 316400 1 0 $X=330670 $Y=312190
X2957 14 8 2149 354 630 ICV_77 $T=381920 214480 1 0 $X=381630 $Y=210270
X2958 1440 1431 1406 8 55 14 CKLNQD1BWP7T $T=236880 222320 0 180 $X=227070 $Y=218110
X2959 1630 1612 1406 8 1477 14 CKLNQD1BWP7T $T=266560 104720 0 180 $X=256750 $Y=100510
X2960 1644 1631 187 8 1519 14 CKLNQD1BWP7T $T=268800 292880 0 180 $X=258990 $Y=288670
X2961 1657 1665 1678 8 1219 14 CKLNQD1BWP7T $T=272160 120400 0 0 $X=271870 $Y=120165
X2962 1671 1650 1406 8 1723 14 CKLNQD1BWP7T $T=273840 96880 0 0 $X=273550 $Y=96645
X2963 1705 1674 1678 8 1281 14 CKLNQD1BWP7T $T=279440 128240 0 0 $X=279150 $Y=128005
X2964 1698 1631 1678 8 1307 14 CKLNQD1BWP7T $T=280000 206640 0 0 $X=279710 $Y=206405
X2965 1689 1724 1678 8 1299 14 CKLNQD1BWP7T $T=280560 214480 0 0 $X=280270 $Y=214245
X2966 2044 1665 1850 8 1945 14 CKLNQD1BWP7T $T=348880 112560 1 180 $X=339070 $Y=112325
X2967 2069 1631 1850 8 2067 14 CKLNQD1BWP7T $T=353920 285040 0 0 $X=353630 $Y=284805
X2968 2047 2074 1850 8 2093 14 CKLNQD1BWP7T $T=354480 151760 0 0 $X=354190 $Y=151525
X2969 2089 1631 1850 8 2116 14 CKLNQD1BWP7T $T=360080 238000 0 0 $X=359790 $Y=237765
X2970 2142 2140 1850 8 142 14 CKLNQD1BWP7T $T=381920 198800 0 0 $X=381630 $Y=198565
X3078 223 483 14 8 836 584 ICV_86 $T=128800 269360 0 0 $X=128510 $Y=269125
X3079 223 484 14 8 830 911 ICV_86 $T=128800 277200 1 0 $X=128510 $Y=272990
X3080 234 235 14 8 1022 1076 ICV_86 $T=156800 175280 0 0 $X=156510 $Y=175045
X3081 234 485 14 8 968 1061 ICV_86 $T=156800 198800 1 0 $X=156510 $Y=194590
X3082 223 486 14 8 821 1054 ICV_86 $T=156800 316400 1 0 $X=156510 $Y=312190
X3083 232 487 14 8 1075 772 ICV_86 $T=184800 355600 1 0 $X=184510 $Y=351390
X3084 236 270 14 8 1113 1342 ICV_86 $T=212800 143920 1 0 $X=212510 $Y=139710
X3085 234 488 14 8 1180 1370 ICV_86 $T=212800 190960 0 0 $X=212510 $Y=190725
X3086 92 489 14 8 1313 410 ICV_86 $T=212800 245840 1 0 $X=212510 $Y=241630
X3087 92 490 14 8 1314 1329 ICV_86 $T=212800 277200 1 0 $X=212510 $Y=272990
X3088 92 491 14 8 1313 597 ICV_86 $T=240800 238000 1 0 $X=240510 $Y=233790
X3089 283 492 14 8 1571 1666 ICV_86 $T=268800 324240 0 0 $X=268510 $Y=324005
X3090 283 493 14 8 1561 1720 ICV_86 $T=268800 339920 1 0 $X=268510 $Y=335710
X3091 283 494 14 8 1557 1648 ICV_86 $T=268800 355600 1 0 $X=268510 $Y=351390
X3092 283 495 14 8 1537 1502 ICV_86 $T=268800 363440 1 0 $X=268510 $Y=359230
X3093 265 496 14 8 1822 1978 ICV_86 $T=324800 269360 1 0 $X=324510 $Y=265150
X3094 265 497 14 8 2139 2062 ICV_86 $T=380800 292880 0 0 $X=380510 $Y=292645
X3095 265 498 14 8 2139 2046 ICV_86 $T=380800 300720 0 0 $X=380510 $Y=300485
X3096 265 499 14 8 2139 2030 ICV_86 $T=380800 316400 0 0 $X=380510 $Y=316165
X3349 14 8 587 35 874 ICV_98 $T=120960 190960 0 0 $X=120670 $Y=190725
X3350 14 8 856 446 796 ICV_98 $T=122080 245840 1 0 $X=121790 $Y=241630
X3351 14 8 912 230 630 ICV_98 $T=131600 324240 1 0 $X=131310 $Y=320030
X3352 14 8 670 275 100 ICV_98 $T=226240 339920 1 0 $X=225950 $Y=335710
X3353 14 8 1378 477 1214 ICV_98 $T=229600 386960 1 0 $X=229310 $Y=382750
X3354 14 8 1394 277 796 ICV_98 $T=232400 245840 1 0 $X=232110 $Y=241630
X3355 14 8 1811 448 631 ICV_98 $T=298480 324240 1 0 $X=298190 $Y=320030
X3356 14 8 1824 316 630 ICV_98 $T=304640 308560 0 0 $X=304350 $Y=308325
X3357 14 8 2099 348 631 ICV_98 $T=375760 324240 1 0 $X=375470 $Y=320030
X3358 135 500 1637 8 533 14 CKMUX2D1BWP7T $T=361200 143920 1 180 $X=355870 $Y=143685
X3359 135 501 1535 8 561 14 CKMUX2D1BWP7T $T=369040 167440 1 180 $X=363710 $Y=167205
X3360 528 502 2110 8 141 14 CKMUX2D1BWP7T $T=366240 198800 1 0 $X=365950 $Y=194590
X3361 528 503 1951 8 452 14 CKMUX2D1BWP7T $T=370160 183120 0 0 $X=369870 $Y=182885
X3362 528 504 2011 8 534 14 CKMUX2D1BWP7T $T=380800 183120 1 180 $X=375470 $Y=182885
X3363 14 8 1158 1146 417 ICV_99 $T=182000 104720 1 180 $X=178910 $Y=104485
X3364 14 8 1154 1140 417 ICV_99 $T=182000 120400 0 180 $X=178910 $Y=116190
X3365 14 8 1452 1434 417 ICV_99 $T=238000 128240 0 180 $X=234910 $Y=124030
X3366 14 8 77 1564 70 ICV_99 $T=258160 379120 0 180 $X=255070 $Y=374910
X3367 14 8 427 315 98 ICV_99 $T=310240 214480 0 180 $X=307150 $Y=210270
X3368 14 8 319 480 1874 ICV_99 $T=315840 190960 1 180 $X=312750 $Y=190725
X3369 14 8 1934 1860 417 ICV_99 $T=322000 104720 1 180 $X=318910 $Y=104485
X3370 14 8 1925 623 630 ICV_99 $T=322560 308560 1 180 $X=319470 $Y=308325
X3371 14 8 2136 392 630 ICV_99 $T=378000 214480 0 180 $X=374910 $Y=210270
X3372 827 664 844 8 835 14 IND3D1BWP7T $T=109200 183120 0 0 $X=108910 $Y=182885
X3373 839 834 36 8 507 14 IND3D1BWP7T $T=114240 190960 1 180 $X=110590 $Y=190725
X3374 508 855 864 8 787 14 IND3D1BWP7T $T=115360 206640 1 0 $X=115070 $Y=202430
X3375 884 586 873 8 860 14 IND3D1BWP7T $T=123760 230160 0 180 $X=120110 $Y=225950
X3376 885 863 857 8 747 14 IND3D1BWP7T $T=122080 300720 0 0 $X=121790 $Y=300485
X3377 896 668 879 8 626 14 IND3D1BWP7T $T=126560 214480 0 180 $X=122910 $Y=210270
X3378 886 396 168 8 576 14 IND3D1BWP7T $T=136080 167440 1 180 $X=132430 $Y=167205
X3379 748 931 168 8 928 14 IND3D1BWP7T $T=138320 190960 0 180 $X=134670 $Y=186750
X3380 922 665 940 8 632 14 IND3D1BWP7T $T=142240 230160 0 180 $X=138590 $Y=225950
X3381 995 970 986 8 749 14 IND3D1BWP7T $T=150640 339920 1 0 $X=150350 $Y=335710
X3382 1357 1282 1317 8 756 14 IND3D1BWP7T $T=222320 285040 0 0 $X=222030 $Y=284805
X3383 1374 408 1403 8 1410 14 IND3D1BWP7T $T=224560 183120 0 0 $X=224270 $Y=182885
X3384 1382 597 1376 8 32 14 IND3D1BWP7T $T=225680 245840 0 0 $X=225390 $Y=245605
X3385 1408 1487 784 8 635 14 IND3D1BWP7T $T=243600 183120 1 0 $X=243310 $Y=178910
X3386 1541 1312 1525 8 1523 14 IND3D1BWP7T $T=253680 183120 0 180 $X=250030 $Y=178910
X3387 69 1617 1600 8 420 14 IND3D1BWP7T $T=273280 112560 0 180 $X=269630 $Y=108350
X3388 1673 1662 1629 8 515 14 IND3D1BWP7T $T=276080 104720 0 180 $X=272430 $Y=100510
X3389 1693 1712 682 8 1663 14 IND3D1BWP7T $T=282240 198800 0 180 $X=278590 $Y=194590
X3390 108 cfg_we_dbg 102 8 1874 14 IND3D1BWP7T $T=334880 151760 0 0 $X=334590 $Y=151525
X3391 99 cfg_we_dbg 2032 8 1964 14 IND3D1BWP7T $T=342160 143920 0 0 $X=341870 $Y=143685
X3392 2112 139 2122 8 2140 14 IND3D1BWP7T $T=372400 206640 1 0 $X=372110 $Y=202430
X3393 2127 139 134 8 2074 14 IND3D1BWP7T $T=374080 175280 0 0 $X=373790 $Y=175045
X3427 23 505 8 21 14 OR2D1BWP7T $T=95760 206640 0 0 $X=95470 $Y=206405
X3428 751 506 8 818 14 OR2D1BWP7T $T=109200 167440 1 180 $X=106110 $Y=167205
X3429 21 507 8 508 14 OR2D1BWP7T $T=110320 206640 1 0 $X=110030 $Y=202430
X3430 847 508 8 786 14 OR2D1BWP7T $T=114240 214480 0 180 $X=111150 $Y=210270
X3431 954 509 8 403 14 OR2D1BWP7T $T=142240 183120 0 180 $X=139150 $Y=178910
X3432 886 510 8 402 14 OR2D1BWP7T $T=146160 159600 0 180 $X=143070 $Y=155390
X3433 1258 511 8 1286 14 OR2D1BWP7T $T=215040 371280 0 0 $X=214750 $Y=371045
X3434 414 512 8 1539 14 OR2D1BWP7T $T=249200 112560 1 0 $X=248910 $Y=108350
X3435 1592 513 8 414 14 OR2D1BWP7T $T=257040 89040 0 180 $X=253950 $Y=84830
X3436 1628 514 8 796 14 OR2D1BWP7T $T=267120 230160 0 180 $X=264030 $Y=225950
X3437 1653 515 8 437 14 OR2D1BWP7T $T=276640 104720 1 0 $X=276350 $Y=100510
X3438 430 516 8 431 14 OR2D1BWP7T $T=283920 190960 1 0 $X=283630 $Y=186750
X3439 bit_error 517 8 1546 14 OR2D1BWP7T $T=323680 324240 0 180 $X=320590 $Y=320030
X3440 123 517 8 1504 14 OR2D1BWP7T $T=324240 245840 1 180 $X=321150 $Y=245605
X3441 1928 518 8 1829 14 OR2D1BWP7T $T=329840 347760 1 180 $X=326750 $Y=347525
X3442 2022 519 8 108 14 OR2D1BWP7T $T=344400 143920 1 0 $X=344110 $Y=139710
X3443 bit_error 520 8 2134 14 OR2D1BWP7T $T=370160 292880 0 0 $X=369870 $Y=292645
X3444 520 119 8 2137 14 OR2D1BWP7T $T=370720 269360 1 0 $X=370430 $Y=265150
X3445 853 859 8 864 14 CKAN2D1BWP7T $T=116480 214480 1 0 $X=116190 $Y=210270
X3446 880 871 8 854 14 CKAN2D1BWP7T $T=122640 261520 0 180 $X=119550 $Y=257310
X3447 584 668 8 871 14 CKAN2D1BWP7T $T=128240 261520 0 180 $X=125150 $Y=257310
X3448 1240 589 8 1323 14 CKAN2D1BWP7T $T=215600 379120 0 0 $X=215310 $Y=378885
X3449 1358 1323 8 1337 14 CKAN2D1BWP7T $T=222880 386960 0 180 $X=219790 $Y=382750
X3450 408 410 8 1400 14 CKAN2D1BWP7T $T=231840 245840 0 180 $X=228750 $Y=241630
X3451 1498 1488 8 1478 14 CKAN2D1BWP7T $T=246960 324240 0 180 $X=243870 $Y=320030
X3452 1526 1499 8 1488 14 CKAN2D1BWP7T $T=250880 316400 1 180 $X=247790 $Y=316165
X3453 1578 1570 8 1503 14 CKAN2D1BWP7T $T=260960 308560 0 180 $X=257870 $Y=304350
X3454 1648 1619 8 1603 14 CKAN2D1BWP7T $T=267120 355600 1 180 $X=264030 $Y=355365
X3455 1606 1621 8 1570 14 CKAN2D1BWP7T $T=264880 308560 1 0 $X=264590 $Y=304350
X3456 1632 1603 8 1616 14 CKAN2D1BWP7T $T=267680 347760 1 180 $X=264590 $Y=347525
X3457 419 1312 8 1567 14 CKAN2D1BWP7T $T=268800 238000 0 180 $X=265710 $Y=233790
X3458 1502 1704 8 1699 14 CKAN2D1BWP7T $T=281120 363440 1 180 $X=278030 $Y=363205
X3459 1756 1746 8 1498 14 CKAN2D1BWP7T $T=286720 316400 1 180 $X=283630 $Y=316165
X3460 1797 1788 8 1578 14 CKAN2D1BWP7T $T=295120 308560 0 180 $X=292030 $Y=304350
X3461 1712 688 8 1773 14 CKAN2D1BWP7T $T=293440 253680 0 0 $X=293150 $Y=253445
X3462 1853 1840 8 1632 14 CKAN2D1BWP7T $T=304080 347760 0 180 $X=300990 $Y=343550
X3463 1795 1808 8 1916 14 CKAN2D1BWP7T $T=319200 363440 0 0 $X=318910 $Y=363205
X3464 1906 busy 8 123 14 CKAN2D1BWP7T $T=320880 230160 0 0 $X=320590 $Y=229925
X3465 1986 185 8 1995 14 CKAN2D1BWP7T $T=338800 253680 0 0 $X=338510 $Y=253445
X3466 2033 2063 8 1853 14 CKAN2D1BWP7T $T=352800 339920 1 180 $X=349710 $Y=339685
X3467 598 prbs_out 8 629 14 CKAN2D1BWP7T $T=357840 238000 1 0 $X=357550 $Y=233790
X3468 2081 2095 8 2111 14 CKAN2D1BWP7T $T=363440 230160 0 0 $X=363150 $Y=229925
X3469 2118 2108 8 1797 14 CKAN2D1BWP7T $T=367360 222320 1 180 $X=364270 $Y=222085
X3470 2103 527 8 135 14 CKAN2D1BWP7T $T=366240 175280 0 0 $X=365950 $Y=175045
X3471 2103 574 8 528 14 CKAN2D1BWP7T $T=366240 183120 0 0 $X=365950 $Y=182885
X3472 2121 2120 8 1756 14 CKAN2D1BWP7T $T=372400 316400 1 180 $X=369310 $Y=316165
X3473 14 8 939 595 964 983 ICV_102 $T=140000 238000 0 0 $X=139710 $Y=237765
X3474 14 8 1399 774 1424 1465 ICV_102 $T=230720 316400 0 0 $X=230430 $Y=316165
X3475 14 8 1522 76 1564 1589 ICV_102 $T=250880 386960 1 0 $X=250590 $Y=382750
X3476 14 8 1654 1635 1669 1709 ICV_102 $T=269920 89040 0 0 $X=269630 $Y=88805
X3477 14 8 1721 1704 1728 1776 ICV_102 $T=281120 363440 0 0 $X=280830 $Y=363205
X3478 14 8 1733 1741 1761 1789 ICV_102 $T=283360 324240 1 0 $X=283070 $Y=320030
X3479 14 8 1861 1769 1879 1925 ICV_102 $T=309120 316400 0 0 $X=308830 $Y=316165
X3480 14 8 1879 728 1797 1910 ICV_102 $T=310240 300720 0 0 $X=309950 $Y=300485
X3481 14 8 1965 518 1967 2017 ICV_102 $T=333760 371280 1 0 $X=333470 $Y=367070
X3482 14 8 2117 2002 2123 2136 ICV_102 $T=369040 214480 0 0 $X=368750 $Y=214245
X3483 521 8 606 14 INVD0BWP7T $T=104160 206640 0 0 $X=103870 $Y=206405
X3484 153 8 605 14 INVD0BWP7T $T=108080 190960 1 180 $X=106110 $Y=190725
X3485 522 8 1531 14 INVD0BWP7T $T=252560 245840 1 180 $X=250590 $Y=245605
X3486 523 8 1544 14 INVD0BWP7T $T=252000 190960 0 0 $X=251710 $Y=190725
X3487 524 8 1605 14 INVD0BWP7T $T=265440 112560 0 0 $X=265150 $Y=112325
X3488 525 8 1646 14 INVD0BWP7T $T=274960 198800 0 180 $X=272990 $Y=194590
X3489 526 8 2037 14 INVD0BWP7T $T=350000 277200 1 180 $X=348030 $Y=276965
X3490 527 8 574 14 INVD0BWP7T $T=362880 183120 0 0 $X=362590 $Y=182885
X3491 528 8 2122 14 INVD0BWP7T $T=369040 206640 1 0 $X=368750 $Y=202430
X3492 1175 8 972 14 CKBD2BWP7T $T=184800 167440 0 180 $X=181150 $Y=163230
X3493 1281 8 971 14 CKBD2BWP7T $T=208320 128240 1 180 $X=204670 $Y=128005
X3494 1307 8 1030 14 CKBD2BWP7T $T=212800 214480 0 180 $X=209150 $Y=210270
X3495 1300 8 1228 14 CKBD2BWP7T $T=220080 300720 0 180 $X=216430 $Y=296510
X3496 1406 8 822 14 CKBD2BWP7T $T=241920 230160 0 0 $X=241630 $Y=229925
X3497 1186 8 1473 14 CKBD2BWP7T $T=244720 269360 0 0 $X=244430 $Y=269125
X3498 1281 8 1543 14 CKBD2BWP7T $T=250880 128240 0 0 $X=250590 $Y=128005
X3499 1436 8 1314 14 CKBD2BWP7T $T=257040 285040 0 180 $X=253390 $Y=280830
X3500 1219 8 1658 14 CKBD2BWP7T $T=269920 128240 0 0 $X=269630 $Y=128005
X3501 1678 8 1406 14 CKBD2BWP7T $T=277760 104720 0 0 $X=277470 $Y=104485
X3502 1406 8 67 14 CKBD2BWP7T $T=282240 104720 0 0 $X=281950 $Y=104485
X3503 1107 8 1366 14 CKBD2BWP7T $T=282240 151760 0 0 $X=281950 $Y=151525
X3504 1299 8 1796 14 CKBD2BWP7T $T=293440 214480 0 0 $X=293150 $Y=214245
X3505 1055 8 1843 14 CKBD2BWP7T $T=301280 151760 0 0 $X=300990 $Y=151525
X3506 1107 8 1863 14 CKBD2BWP7T $T=308560 167440 0 0 $X=308270 $Y=167205
X3507 2093 8 125 14 CKBD2BWP7T $T=367920 159600 0 0 $X=367630 $Y=159365
X3508 234 529 14 8 1138 1093 ICV_103 $T=169120 230160 0 0 $X=168830 $Y=229925
X3509 73 460 14 8 1548 57 ICV_103 $T=241920 151760 1 0 $X=241630 $Y=147550
X3510 283 530 14 8 1537 1573 ICV_103 $T=255920 371280 1 0 $X=255630 $Y=367070
X3511 283 531 14 8 1557 1619 ICV_103 $T=280560 347760 0 0 $X=280270 $Y=347525
X3512 297 298 14 8 1366 1736 ICV_103 $T=283360 151760 1 0 $X=283070 $Y=147550
X3513 283 532 14 8 1571 1741 ICV_103 $T=283920 324240 0 0 $X=283630 $Y=324005
X3514 139 533 14 8 2072 501 ICV_103 $T=361200 143920 0 0 $X=360910 $Y=143685
X3515 139 534 14 8 142 503 ICV_103 $T=367360 190960 1 0 $X=367070 $Y=186750
X3516 223 535 14 8 830 981 ICV_104 $T=134400 300720 1 0 $X=134110 $Y=296510
X3517 223 536 14 8 821 985 ICV_104 $T=142800 316400 0 0 $X=142510 $Y=316165
X3518 234 537 14 8 1022 1068 ICV_104 $T=157920 190960 0 0 $X=157630 $Y=190725
X3519 234 485 14 8 1022 1049 ICV_104 $T=159600 183120 0 0 $X=159310 $Y=182885
X3520 232 538 14 8 1075 1135 ICV_104 $T=170800 363440 0 0 $X=170510 $Y=363205
X3521 232 539 14 8 1203 1243 ICV_104 $T=189840 363440 1 0 $X=189550 $Y=359230
X3522 92 540 14 8 1315 1318 ICV_104 $T=213920 292880 1 0 $X=213630 $Y=288670
X3523 92 541 14 8 1315 1301 ICV_104 $T=213920 292880 0 0 $X=213630 $Y=292645
X3524 73 542 14 8 1384 1441 ICV_104 $T=226800 143920 1 0 $X=226510 $Y=139710
X3525 232 543 14 8 1368 1240 ICV_104 $T=243040 394800 1 0 $X=242750 $Y=390590
X3526 92 544 14 8 1641 427 ICV_104 $T=272160 230160 0 0 $X=271870 $Y=229925
X3527 92 545 14 8 1641 1712 ICV_104 $T=277200 253680 1 0 $X=276910 $Y=249470
X3528 283 546 14 8 1561 1801 ICV_104 $T=281680 332080 0 0 $X=281390 $Y=331845
X3529 283 547 14 8 1822 1867 ICV_104 $T=299040 277200 1 0 $X=298750 $Y=272990
X3530 139 548 14 8 1796 1905 ICV_104 $T=306880 230160 1 0 $X=306590 $Y=225950
X3531 283 549 14 8 1822 1900 ICV_104 $T=306880 277200 0 0 $X=306590 $Y=276965
X3532 139 550 14 8 1796 1929 ICV_104 $T=310800 206640 1 0 $X=310510 $Y=202430
X3533 139 311 14 8 1863 1924 ICV_104 $T=325920 183120 1 0 $X=325630 $Y=178910
X3534 139 551 14 8 1878 1985 ICV_104 $T=327600 230160 1 0 $X=327310 $Y=225950
X3535 283 552 14 8 1927 599 ICV_104 $T=337680 355600 0 0 $X=337390 $Y=355365
X3536 139 310 14 8 1843 2053 ICV_104 $T=339360 183120 1 0 $X=339070 $Y=178910
X3537 297 553 14 8 2072 2096 ICV_104 $T=353920 136080 1 0 $X=353630 $Y=131870
X3538 139 554 14 8 2072 2131 ICV_104 $T=367360 136080 1 0 $X=367070 $Y=131870
X3539 236 248 14 8 972 751 ICV_105 $T=169120 159600 0 180 $X=157630 $Y=155390
X3540 236 248 14 8 1070 1018 ICV_105 $T=169120 159600 1 180 $X=157630 $Y=159365
X3541 223 555 14 8 1228 1101 ICV_105 $T=200480 277200 1 180 $X=188990 $Y=276965
X3542 92 556 14 8 1228 1202 ICV_105 $T=201600 269360 0 180 $X=190110 $Y=265150
X3543 232 557 14 8 1228 1205 ICV_105 $T=202720 316400 0 180 $X=191230 $Y=312190
X3544 232 558 14 8 1315 1390 ICV_105 $T=238560 332080 0 180 $X=227070 $Y=327870
X3545 283 559 14 8 1571 775 ICV_105 $T=257600 332080 1 180 $X=246110 $Y=331845
X3546 92 560 14 8 1313 677 ICV_105 $T=266000 261520 0 180 $X=254510 $Y=257310
X3547 139 314 14 8 1863 1807 ICV_105 $T=309120 175280 0 180 $X=297630 $Y=171070
X3548 139 382 14 8 1783 1750 ICV_105 $T=322560 175280 0 180 $X=311070 $Y=171070
X3549 265 196 14 8 2067 603 ICV_105 $T=366240 285040 0 180 $X=354750 $Y=280830
X3550 265 211 14 8 2116 2057 ICV_105 $T=374080 253680 1 180 $X=362590 $Y=253445
X3551 139 561 14 8 125 2105 ICV_105 $T=378000 167440 0 180 $X=366510 $Y=163230
X3552 265 342 14 8 2116 2092 ICV_105 $T=378000 261520 0 180 $X=366510 $Y=257310
X3553 223 562 14 8 916 941 ICV_106 $T=132160 324240 0 0 $X=131870 $Y=324005
X3554 223 563 14 8 830 948 ICV_106 $T=132720 261520 1 0 $X=132430 $Y=257310
X3555 236 237 14 8 972 886 ICV_106 $T=144480 151760 0 0 $X=144190 $Y=151525
X3556 234 564 14 8 1180 1207 ICV_106 $T=185920 214480 1 0 $X=185630 $Y=210270
X3557 234 261 14 8 1070 1210 ICV_106 $T=187040 167440 1 0 $X=186750 $Y=163230
X3558 234 262 14 8 1070 1218 ICV_106 $T=187040 175280 0 0 $X=186750 $Y=175045
X3559 234 565 14 8 1180 1279 ICV_106 $T=196560 190960 1 0 $X=196270 $Y=186750
X3560 232 566 14 8 1229 1529 ICV_106 $T=241920 339920 1 0 $X=241630 $Y=335710
X3561 73 293 14 8 1366 1559 ICV_106 $T=244720 143920 1 0 $X=244430 $Y=139710
X3562 92 415 14 8 822 514 ICV_106 $T=247520 230160 1 0 $X=247230 $Y=225950
X3563 283 567 14 8 1537 511 ICV_106 $T=284480 371280 1 0 $X=284190 $Y=367070
X3564 139 388 14 8 1863 1906 ICV_106 $T=308000 190960 1 0 $X=307710 $Y=186750
X3565 265 568 14 8 1822 1930 ICV_106 $T=312480 277200 1 0 $X=312190 $Y=272990
X3566 139 569 14 8 1878 1979 ICV_106 $T=325920 222320 1 0 $X=325630 $Y=218110
X3567 283 570 14 8 1822 1987 ICV_106 $T=328160 308560 1 0 $X=327870 $Y=304350
X3568 139 382 14 8 1843 2011 ICV_106 $T=337120 167440 1 0 $X=336830 $Y=163230
X3569 265 571 14 8 2067 2097 ICV_106 $T=365120 308560 1 0 $X=364830 $Y=304350
X3570 591 807 8 801 14 IND2D1BWP7T $T=96320 222320 1 0 $X=96030 $Y=218110
X3571 593 153 8 805 14 IND2D1BWP7T $T=102480 190960 0 0 $X=102190 $Y=190725
X3572 793 521 8 798 14 IND2D1BWP7T $T=106960 214480 1 180 $X=103870 $Y=214245
X3573 751 833 8 815 14 IND2D1BWP7T $T=109200 159600 1 0 $X=108910 $Y=155390
X3574 664 827 8 841 14 IND2D1BWP7T $T=111440 183120 1 0 $X=111150 $Y=178910
X3575 838 396 8 849 14 IND2D1BWP7T $T=114240 175280 1 0 $X=113950 $Y=171070
X3576 587 874 8 834 14 IND2D1BWP7T $T=116480 190960 0 0 $X=116190 $Y=190725
X3577 894 584 8 848 14 IND2D1BWP7T $T=122640 206640 1 180 $X=119550 $Y=206405
X3578 581 166 8 873 14 IND2D1BWP7T $T=123200 222320 0 0 $X=122910 $Y=222085
X3579 586 884 8 895 14 IND2D1BWP7T $T=123200 230160 0 0 $X=122910 $Y=229925
X3580 584 894 8 879 14 IND2D1BWP7T $T=127680 206640 1 180 $X=124590 $Y=206405
X3581 910 168 8 903 14 IND2D1BWP7T $T=131600 175280 1 0 $X=131310 $Y=171070
X3582 665 922 8 921 14 IND2D1BWP7T $T=136640 230160 0 180 $X=133550 $Y=225950
X3583 750 41 8 782 14 IND2D1BWP7T $T=140000 175280 1 180 $X=136910 $Y=175045
X3584 595 406 8 934 14 IND2D1BWP7T $T=142800 206640 1 180 $X=139710 $Y=206405
X3585 950 592 8 947 14 IND2D1BWP7T $T=141120 222320 1 0 $X=140830 $Y=218110
X3586 592 950 8 940 14 IND2D1BWP7T $T=143920 222320 1 180 $X=140830 $Y=222085
X3587 946 509 8 960 14 IND2D1BWP7T $T=141680 175280 0 0 $X=141390 $Y=175045
X3588 596 411 8 784 14 IND2D1BWP7T $T=236320 183120 1 0 $X=236030 $Y=178910
X3589 959 1469 8 1474 14 IND2D1BWP7T $T=245840 120400 0 180 $X=242750 $Y=116190
X3590 1492 92 8 572 14 IND2D1BWP7T $T=246960 214480 1 180 $X=243870 $Y=214245
X3591 1469 959 8 731 14 IND2D1BWP7T $T=247520 112560 1 180 $X=244430 $Y=112325
X3592 1475 66 8 1482 14 IND2D1BWP7T $T=247520 159600 1 180 $X=244430 $Y=159365
X3593 597 413 8 1487 14 IND2D1BWP7T $T=247520 175280 1 180 $X=244430 $Y=175045
X3594 522 92 8 415 14 IND2D1BWP7T $T=254240 230160 1 180 $X=251150 $Y=229925
X3595 1312 1541 8 1565 14 IND2D1BWP7T $T=258160 183120 0 180 $X=255070 $Y=178910
X3596 1592 513 8 573 14 IND2D1BWP7T $T=262080 112560 1 180 $X=258990 $Y=112325
X3597 1608 1405 8 1595 14 IND2D1BWP7T $T=264320 183120 0 180 $X=261230 $Y=178910
X3598 677 418 8 785 14 IND2D1BWP7T $T=268800 198800 0 180 $X=265710 $Y=194590
X3599 688 525 8 682 14 IND2D1BWP7T $T=274960 198800 1 0 $X=274670 $Y=194590
X3600 757 426 8 1681 14 IND2D1BWP7T $T=280000 183120 0 180 $X=276910 $Y=178910
X3601 1712 1693 8 1703 14 IND2D1BWP7T $T=282800 190960 1 180 $X=279710 $Y=190725
X3602 1767 92 8 1724 14 IND2D1BWP7T $T=287840 238000 1 180 $X=284750 $Y=237765
X3603 1743 1750 8 1744 14 IND2D1BWP7T $T=288400 183120 0 180 $X=285310 $Y=178910
X3604 1750 1716 8 758 14 IND2D1BWP7T $T=288960 175280 0 180 $X=285870 $Y=171070
X3605 1760 1364 8 1757 14 IND2D1BWP7T $T=288400 198800 1 0 $X=288110 $Y=194590
X3606 1814 1781 8 1673 14 IND2D1BWP7T $T=294560 89040 0 180 $X=291470 $Y=84830
X3607 1364 1778 8 615 14 IND2D1BWP7T $T=295120 183120 1 180 $X=292030 $Y=182885
X3608 1874 310 8 435 14 IND2D1BWP7T $T=308000 190960 1 180 $X=304910 $Y=190725
X3609 520 1857 8 1767 14 IND2D1BWP7T $T=309680 245840 0 180 $X=306590 $Y=241630
X3610 520 283 8 1726 14 IND2D1BWP7T $T=314160 285040 1 180 $X=311070 $Y=284805
X3611 1874 321 8 438 14 IND2D1BWP7T $T=318080 190960 0 0 $X=317790 $Y=190725
X3612 1214 rst_n 8 517 14 IND2D1BWP7T $T=320320 277200 0 0 $X=320030 $Y=276965
X3613 1837 bit_error 8 1857 14 IND2D1BWP7T $T=320880 245840 1 0 $X=320590 $Y=241630
X3614 109 2032 8 2027 14 IND2D1BWP7T $T=343840 159600 0 0 $X=343550 $Y=159365
X3615 101 107 8 2019 14 IND2D1BWP7T $T=347760 151760 0 0 $X=347470 $Y=151525
X3616 input_select_dbg prbs_out 8 2081 14 IND2D1BWP7T $T=355600 230160 1 0 $X=355310 $Y=225950
X3617 520 100 8 2114 14 IND2D1BWP7T $T=365120 269360 0 0 $X=364830 $Y=269125
X3618 44 954 8 965 14 XNR2D1BWP7T $T=139440 167440 0 0 $X=139150 $Y=167205
X3619 1654 1662 8 1793 14 XNR2D1BWP7T $T=282240 96880 1 0 $X=281950 $Y=92670
X3620 1908 1896 8 1936 14 XNR2D1BWP7T $T=319760 89040 1 0 $X=319470 $Y=84830
X3621 checker_in_final 2111 8 124 14 XNR2D1BWP7T $T=370160 245840 0 180 $X=364830 $Y=241630
X3622 1531 1518 92 822 8 119 14 EDFKCNQD1BWP7T $T=250320 253680 1 0 $X=250030 $Y=249470
X3623 194 1767 92 94 8 1837 14 EDFKCNQD1BWP7T $T=297920 238000 0 0 $X=297630 $Y=237765
X3624 2052 2114 265 94 8 2039 14 EDFKCNQD1BWP7T $T=369040 269360 0 180 $X=353630 $Y=265150
X3625 2129 2134 265 94 8 1841 14 EDFKCNQD1BWP7T $T=378000 300720 0 180 $X=362590 $Y=296510
X3626 2090 2137 265 94 8 112 14 EDFKCNQD1BWP7T $T=379680 261520 1 180 $X=364270 $Y=261285
X3627 166 8 883 14 CKND1BWP7T $T=126000 222320 0 0 $X=125710 $Y=222085
X3628 572 8 788 14 CKND1BWP7T $T=244160 214480 1 180 $X=242190 $Y=214245
X3629 573 8 1509 14 CKND1BWP7T $T=249760 112560 1 180 $X=247790 $Y=112325
X3630 574 8 mode_select_dbg 14 CKND1BWP7T $T=366240 206640 0 180 $X=364270 $Y=202430
X3655 14 8 869 227 630 ICV_109 $T=110880 324240 1 0 $X=110590 $Y=320030
X3656 14 8 902 228 630 ICV_109 $T=123200 285040 0 0 $X=122910 $Y=284805
X3657 14 8 932 469 796 ICV_109 $T=150080 238000 0 0 $X=149790 $Y=237765
X3658 14 8 1122 374 630 ICV_109 $T=171920 308560 1 0 $X=171630 $Y=304350
X3659 14 8 585 557 100 ICV_109 $T=204960 316400 1 0 $X=204670 $Y=312190
X3660 14 8 1454 543 1214 ICV_109 $T=234640 386960 1 0 $X=234350 $Y=382750
X3661 14 8 1493 491 796 ICV_109 $T=241920 238000 0 0 $X=241630 $Y=237765
X3662 14 8 1532 559 631 ICV_109 $T=250320 324240 0 0 $X=250030 $Y=324005
X3663 14 8 1593 761 630 ICV_109 $T=257040 308560 0 0 $X=256750 $Y=308325
X3664 14 8 1579 746 100 ICV_109 $T=262080 316400 0 0 $X=261790 $Y=316165
X3665 14 8 1975 466 1214 ICV_109 $T=332640 371280 0 0 $X=332350 $Y=371045
X3666 14 8 2100 337 630 ICV_109 $T=360080 214480 1 0 $X=359790 $Y=210270
X3667 14 8 2106 341 438 ICV_109 $T=362320 339920 1 0 $X=362030 $Y=335710
X3668 506 575 802 8 521 14 AO21D0BWP7T $T=107520 183120 0 180 $X=103870 $Y=178910
X3669 510 576 881 8 39 14 AO21D0BWP7T $T=126560 167440 1 180 $X=122910 $Y=167205
X3670 730 421 1608 8 416 14 AO21D0BWP7T $T=266000 175280 1 180 $X=262350 $Y=175045
X3671 2087 577 2015 8 2110 14 AO21D0BWP7T $T=359520 198800 1 0 $X=359230 $Y=194590
X3672 929 914 747 400 8 924 14 NR4D0BWP7T $T=135520 300720 1 180 $X=131870 $Y=300485
X3673 961 982 749 407 8 991 14 NR4D0BWP7T $T=146720 339920 0 0 $X=146430 $Y=339685
X3674 945 509 954 748 8 1100 14 NR4D0BWP7T $T=166320 183120 1 0 $X=166030 $Y=178910
X3675 1265 1267 753 183 8 1262 14 NR4D0BWP7T $T=204400 379120 1 0 $X=204110 $Y=374910
X3676 590 582 1243 1286 8 672 14 NR4D0BWP7T $T=205520 347760 0 0 $X=205230 $Y=347525
X3677 583 1252 1292 1387 8 1398 14 NR4D0BWP7T $T=215600 355600 0 0 $X=215310 $Y=355365
X3678 1350 1295 1253 1321 8 1333 14 NR4D0BWP7T $T=221200 230160 1 180 $X=217550 $Y=229925
X3679 1360 1363 756 409 8 1386 14 NR4D0BWP7T $T=226800 277200 1 0 $X=226510 $Y=272990
X3680 74 1302 670 588 8 671 14 NR4D0BWP7T $T=231280 355600 0 180 $X=227630 $Y=351390
X3681 1422 645 589 1316 8 1415 14 NR4D0BWP7T $T=232400 355600 1 180 $X=228750 $Y=355365
X3682 1450 1490 1497 1475 8 61 14 NR4D0BWP7T $T=244720 159600 1 0 $X=244430 $Y=155390
X3683 1553 1502 669 585 8 1479 14 NR4D0BWP7T $T=248640 355600 1 180 $X=244990 $Y=355365
X3684 1324 1508 1513 1524 8 1496 14 NR4D0BWP7T $T=246960 222320 1 0 $X=246670 $Y=218110
X3685 1604 76 1240 1573 8 1451 14 NR4D0BWP7T $T=263760 363440 0 180 $X=260110 $Y=359230
X3686 1667 1750 433 757 8 1209 14 NR4D0BWP7T $T=290080 167440 0 0 $X=289790 $Y=167205
X3687 1808 1815 1704 1829 8 726 14 NR4D0BWP7T $T=297920 347760 1 0 $X=297630 $Y=343550
X3688 1951 2011 2056 2060 8 577 14 NR4D0BWP7T $T=358400 198800 0 180 $X=354750 $Y=194590
X3689 1685 1818 2056 2042 8 2075 14 NR4D0BWP7T $T=360080 190960 0 180 $X=356430 $Y=186750
X3690 1535 1806 1951 2053 8 2077 14 NR4D0BWP7T $T=361200 183120 0 180 $X=357550 $Y=178910
X3691 1637 1798 2011 2060 8 2085 14 NR4D0BWP7T $T=359520 175280 1 0 $X=359230 $Y=171070
X3692 879 578 891 8 853 14 INR3D0BWP7T $T=121520 214480 0 0 $X=121230 $Y=214245
X3693 934 579 633 8 859 14 INR3D0BWP7T $T=137760 214480 0 180 $X=133550 $Y=210270
X3694 2085 580 1640 8 2082 14 INR3D0BWP7T $T=358400 175280 0 0 $X=358110 $Y=175045
X3695 1258 627 120 1282 581 612 8 657 14 AOI222D0BWP7T $T=203280 285040 0 0 $X=202990 $Y=284805
X3696 399 612 120 1311 582 627 8 659 14 AOI222D0BWP7T $T=203840 261520 1 0 $X=203550 $Y=257310
X3697 664 612 120 1306 583 627 8 663 14 AOI222D0BWP7T $T=203840 269360 1 0 $X=203550 $Y=265150
X3698 1240 627 120 1301 584 612 8 708 14 AOI222D0BWP7T $T=203840 292880 1 0 $X=203550 $Y=288670
X3699 665 612 120 1309 585 627 8 714 14 AOI222D0BWP7T $T=203840 308560 0 0 $X=203550 $Y=308325
X3700 645 627 120 1317 586 612 8 649 14 AOI222D0BWP7T $T=204400 277200 0 0 $X=204110 $Y=276965
X3701 1252 627 120 1318 587 612 8 712 14 AOI222D0BWP7T $T=204400 285040 1 0 $X=204110 $Y=280830
X3702 398 612 120 1329 588 627 8 661 14 AOI222D0BWP7T $T=206080 269360 0 0 $X=205790 $Y=269125
X3703 668 612 120 1298 589 627 8 651 14 AOI222D0BWP7T $T=207200 292880 0 0 $X=206910 $Y=292645
X3704 793 612 120 1328 590 627 8 653 14 AOI222D0BWP7T $T=207760 261520 0 0 $X=207470 $Y=261285
X3705 1243 627 120 1351 591 612 8 706 14 AOI222D0BWP7T $T=213920 269360 1 0 $X=213630 $Y=265150
X3706 669 627 120 1334 592 612 8 710 14 AOI222D0BWP7T $T=215040 300720 0 0 $X=214750 $Y=300485
X3707 1302 627 120 1353 593 612 8 718 14 AOI222D0BWP7T $T=216160 253680 1 0 $X=215870 $Y=249470
X3708 1292 627 120 1365 394 612 8 655 14 AOI222D0BWP7T $T=216160 253680 0 0 $X=215870 $Y=253445
X3709 1316 627 120 774 594 612 8 667 14 AOI222D0BWP7T $T=216160 308560 0 0 $X=215870 $Y=308325
X3710 670 627 120 1390 595 612 8 716 14 AOI222D0BWP7T $T=216160 316400 1 0 $X=215870 $Y=312190
X3711 410 612 120 1442 74 627 8 674 14 AOI222D0BWP7T $T=235760 300720 0 0 $X=235470 $Y=300485
X3712 76 627 120 775 408 612 8 676 14 AOI222D0BWP7T $T=254800 292880 0 180 $X=249470 $Y=288670
X3713 1579 627 120 1526 596 612 8 679 14 AOI222D0BWP7T $T=259840 292880 1 180 $X=254510 $Y=292645
X3714 1573 627 120 1499 597 612 8 681 14 AOI222D0BWP7T $T=260400 300720 1 180 $X=255070 $Y=300485
X3715 1502 627 120 1666 419 612 8 685 14 AOI222D0BWP7T $T=271600 308560 1 0 $X=271310 $Y=304350
X3716 2005 609 1071 1997 598 checker_in_final 8 701 14 AOI222D0BWP7T $T=345520 308560 0 180 $X=340190 $Y=304350
X3717 checker_in 598 614 done mode_select_dbg 613 8 2009 14 AOI222D0BWP7T $T=347200 230160 1 180 $X=341870 $Y=229925
X3718 119 614 526 2038 518 627 8 1983 14 AOI222D0BWP7T $T=342720 261520 0 0 $X=342430 $Y=261285
X3719 2046 120 526 2007 599 609 8 694 14 AOI222D0BWP7T $T=349440 300720 1 180 $X=344110 $Y=300485
X3720 2030 120 526 2059 600 609 8 720 14 AOI222D0BWP7T $T=346080 308560 1 0 $X=345790 $Y=304350
X3721 1905 1046 614 mode_select_dbg 601 116 8 702 14 AOI222D0BWP7T $T=347760 230160 1 0 $X=347470 $Y=225950
X3722 2079 120 526 2091 602 609 8 696 14 AOI222D0BWP7T $T=356720 300720 0 0 $X=356430 $Y=300485
X3723 1841 114 116 2109 603 526 8 2031 14 AOI222D0BWP7T $T=357280 261520 1 0 $X=356990 $Y=257310
X3724 2083 120 526 2097 604 609 8 2010 14 AOI222D0BWP7T $T=357840 308560 0 0 $X=357550 $Y=308325
X3725 593 605 805 804 8 28 14 AOI22D0BWP7T $T=106960 198800 0 180 $X=103310 $Y=194590
X3726 793 606 798 810 8 25 14 AOI22D0BWP7T $T=106960 214480 0 180 $X=103310 $Y=210270
X3727 595 607 934 984 8 919 14 AOI22D0BWP7T $T=140560 214480 0 0 $X=140270 $Y=214245
X3728 911 608 610 973 8 1003 14 AOI22D0BWP7T $T=152320 285040 0 180 $X=148670 $Y=280830
X3729 872 608 610 998 8 989 14 AOI22D0BWP7T $T=148960 285040 0 0 $X=148670 $Y=284805
X3730 857 608 609 986 8 1010 14 AOI22D0BWP7T $T=152320 308560 1 180 $X=148670 $Y=308325
X3731 893 608 610 1001 8 990 14 AOI22D0BWP7T $T=150080 292880 1 0 $X=149790 $Y=288670
X3732 906 608 609 936 8 1016 14 AOI22D0BWP7T $T=155120 316400 0 180 $X=151470 $Y=312190
X3733 925 608 609 941 8 1008 14 AOI22D0BWP7T $T=155680 324240 0 180 $X=152030 $Y=320030
X3734 948 608 610 1011 8 1004 14 AOI22D0BWP7T $T=152880 261520 0 0 $X=152590 $Y=261285
X3735 949 608 610 1018 8 1005 14 AOI22D0BWP7T $T=153440 269360 1 0 $X=153150 $Y=265150
X3736 1023 609 1071 1092 8 705 14 AOI22D0BWP7T $T=166320 324240 0 0 $X=166030 $Y=324005
X3737 1048 609 1071 1123 8 650 14 AOI22D0BWP7T $T=169120 339920 0 0 $X=168830 $Y=339685
X3738 1028 609 1071 1109 8 707 14 AOI22D0BWP7T $T=170240 339920 1 0 $X=169950 $Y=335710
X3739 1040 609 1071 1168 8 652 14 AOI22D0BWP7T $T=171920 324240 1 0 $X=171630 $Y=320030
X3740 886 200 613 1155 8 1130 14 AOI22D0BWP7T $T=176400 167440 1 0 $X=176110 $Y=163230
X3741 1099 609 1071 1161 8 654 14 AOI22D0BWP7T $T=176400 316400 0 0 $X=176110 $Y=316165
X3742 751 200 613 1151 8 1132 14 AOI22D0BWP7T $T=176960 159600 0 0 $X=176670 $Y=159365
X3743 985 608 609 1135 8 1121 14 AOI22D0BWP7T $T=176960 316400 1 0 $X=176670 $Y=312190
X3744 1103 609 1071 1148 8 709 14 AOI22D0BWP7T $T=176960 339920 1 0 $X=176670 $Y=335710
X3745 863 608 1071 1194 8 1181 14 AOI22D0BWP7T $T=185920 316400 0 0 $X=185630 $Y=316165
X3746 975 608 1071 1196 8 1242 14 AOI22D0BWP7T $T=193760 285040 0 180 $X=190110 $Y=280830
X3747 1232 610 1071 1205 8 713 14 AOI22D0BWP7T $T=194320 308560 0 180 $X=190670 $Y=304350
X3748 1210 610 1071 1220 8 660 14 AOI22D0BWP7T $T=192080 277200 1 0 $X=191790 $Y=272990
X3749 1231 610 1071 1211 8 662 14 AOI22D0BWP7T $T=197120 261520 0 180 $X=193470 $Y=257310
X3750 1139 609 1071 1268 8 715 14 AOI22D0BWP7T $T=199920 339920 1 0 $X=199630 $Y=335710
X3751 771 608 610 1269 8 1260 14 AOI22D0BWP7T $T=202160 300720 0 0 $X=201870 $Y=300485
X3752 772 609 1071 1296 8 666 14 AOI22D0BWP7T $T=206640 339920 1 0 $X=206350 $Y=335710
X3753 56 200 613 1453 8 1439 14 AOI22D0BWP7T $T=235760 151760 0 0 $X=235470 $Y=151525
X3754 1458 608 610 1441 8 1467 14 AOI22D0BWP7T $T=240240 300720 0 180 $X=236590 $Y=296510
X3755 57 200 613 1470 8 1500 14 AOI22D0BWP7T $T=246960 151760 1 180 $X=243310 $Y=151525
X3756 1484 609 1071 1529 8 673 14 AOI22D0BWP7T $T=245280 347760 1 0 $X=244990 $Y=343550
X3757 1535 610 1071 1506 8 675 14 AOI22D0BWP7T $T=251440 269360 1 180 $X=247790 $Y=269125
X3758 1450 200 613 1559 8 1534 14 AOI22D0BWP7T $T=251440 151760 0 0 $X=251150 $Y=151525
X3759 1606 608 1071 1634 8 1615 14 AOI22D0BWP7T $T=264320 300720 0 0 $X=264030 $Y=300485
X3760 1648 609 610 1637 8 678 14 AOI22D0BWP7T $T=273280 300720 1 180 $X=269630 $Y=300485
X3761 1679 611 1622 1611 8 1670 14 AOI22D0BWP7T $T=276080 190960 0 180 $X=272430 $Y=186750
X3762 1621 608 610 1685 8 1645 14 AOI22D0BWP7T $T=273280 300720 0 0 $X=272990 $Y=300485
X3763 1700 609 1071 1720 8 684 14 AOI22D0BWP7T $T=278320 332080 0 0 $X=278030 $Y=331845
X3764 1741 120 608 1769 8 686 14 AOI22D0BWP7T $T=286160 308560 0 0 $X=285870 $Y=308325
X3765 1730 120 608 1784 8 1774 14 AOI22D0BWP7T $T=289520 308560 0 0 $X=289230 $Y=308325
X3766 1803 608 610 1640 8 1711 14 AOI22D0BWP7T $T=293440 300720 1 180 $X=289790 $Y=300485
X3767 1820 609 1071 1765 8 687 14 AOI22D0BWP7T $T=295120 339920 1 180 $X=291470 $Y=339685
X3768 1798 610 613 1736 8 1790 14 AOI22D0BWP7T $T=295680 183120 0 180 $X=292030 $Y=178910
X3769 727 120 608 728 8 691 14 AOI22D0BWP7T $T=299600 308560 0 0 $X=299310 $Y=308325
X3770 1827 609 1071 1804 8 689 14 AOI22D0BWP7T $T=303520 339920 0 180 $X=299870 $Y=335710
X3771 433 200 627 1795 8 1907 14 AOI22D0BWP7T $T=318080 222320 0 0 $X=317790 $Y=222085
X3772 434 200 1046 1929 8 1917 14 AOI22D0BWP7T $T=320320 198800 0 0 $X=320030 $Y=198565
X3773 688 612 1071 1930 8 1926 14 AOI22D0BWP7T $T=321440 269360 1 0 $X=321150 $Y=265150
X3774 1719 612 627 1928 8 643 14 AOI22D0BWP7T $T=333200 285040 0 180 $X=329550 $Y=280830
X3775 427 612 627 1422 8 647 14 AOI22D0BWP7T $T=333760 261520 0 180 $X=330110 $Y=257310
X3776 1712 612 1071 1931 8 1959 14 AOI22D0BWP7T $T=334320 300720 1 180 $X=330670 $Y=300485
X3777 inject_error_enable_dbg 613 1642 1979 8 1996 14 AOI22D0BWP7T $T=341600 222320 0 180 $X=337950 $Y=218110
X3778 2015 610 1999 1987 8 698 14 AOI22D0BWP7T $T=343280 245840 0 180 $X=339630 $Y=241630
X3779 790 613 1642 1985 8 2016 14 AOI22D0BWP7T $T=344400 230160 0 180 $X=340750 $Y=225950
X3780 2042 610 613 input_select_dbg 8 700 14 AOI22D0BWP7T $T=345520 198800 1 180 $X=341870 $Y=198565
X3781 2054 608 1642 1991 8 2028 14 AOI22D0BWP7T $T=349440 238000 1 180 $X=345790 $Y=237765
X3782 2065 608 1642 1933 8 2034 14 AOI22D0BWP7T $T=349440 245840 0 180 $X=345790 $Y=241630
X3783 2036 608 610 2060 8 722 14 AOI22D0BWP7T $T=347200 222320 1 0 $X=346910 $Y=218110
X3784 2040 608 610 2056 8 703 14 AOI22D0BWP7T $T=347760 214480 1 0 $X=347470 $Y=210270
X3785 2039 614 116 2068 8 1887 14 AOI22D0BWP7T $T=347760 245840 0 0 $X=347470 $Y=245605
X3786 inject_error_enable_dbg 614 116 2057 8 1899 14 AOI22D0BWP7T $T=347760 253680 0 0 $X=347470 $Y=253445
X3787 input_select_dbg 614 116 2092 8 1976 14 AOI22D0BWP7T $T=356160 253680 0 0 $X=355870 $Y=253445
X3788 2132 120 609 2078 8 2066 14 AOI22D0BWP7T $T=361200 292880 0 180 $X=357550 $Y=288670
X3789 615 431 8 428 14 NR2D2BWP7T $T=289520 183120 1 180 $X=285310 $Y=182885
X3790 108 1962 8 612 14 NR2D2BWP7T $T=336000 190960 1 180 $X=331790 $Y=190725
X3791 616 2000 8 627 14 NR2D2BWP7T $T=343280 206640 1 180 $X=339070 $Y=206405
X3792 616 2027 8 608 14 NR2D2BWP7T $T=345520 198800 1 0 $X=345230 $Y=194590
X3793 108 2035 8 613 14 NR2D2BWP7T $T=348880 198800 0 0 $X=348590 $Y=198565
X3794 617 2027 8 120 14 NR2D2BWP7T $T=355600 206640 0 0 $X=355310 $Y=206405
X3795 617 2035 8 609 14 NR2D2BWP7T $T=356160 214480 1 0 $X=355870 $Y=210270
X3796 1480 1496 1333 522 8 1518 14 AO31D1BWP7T $T=245280 230160 0 0 $X=244990 $Y=229925
X3797 cfg_we_dbg 440 102 1935 8 1701 14 AO31D1BWP7T $T=330960 151760 0 180 $X=326190 $Y=147550
X3798 2077 2075 2082 2015 8 130 14 AO31D1BWP7T $T=356160 183120 0 0 $X=355870 $Y=182885
X3799 797 799 805 8 23 14 IOA21D1BWP7T $T=96880 198800 1 0 $X=96590 $Y=194590
X3800 819 751 575 8 807 14 IOA21D1BWP7T $T=108080 175280 1 180 $X=104430 $Y=175045
X3801 883 581 860 8 851 14 IOA21D1BWP7T $T=120960 222320 1 180 $X=117310 $Y=222085
X3802 40 886 576 8 874 14 IOA21D1BWP7T $T=124320 175280 0 180 $X=120670 $Y=171070
X3803 903 750 890 8 884 14 IOA21D1BWP7T $T=127680 206640 0 180 $X=124030 $Y=202430
X3804 926 754 901 8 896 14 IOA21D1BWP7T $T=134960 198800 1 180 $X=131310 $Y=198565
X3805 901 755 903 8 894 14 IOA21D1BWP7T $T=134960 206640 0 180 $X=131310 $Y=202430
X3806 942 748 928 8 922 14 IOA21D1BWP7T $T=139440 198800 0 180 $X=135790 $Y=194590
X3807 928 945 926 8 950 14 IOA21D1BWP7T $T=138880 198800 0 0 $X=138590 $Y=198565
X3808 1374 1402 1403 8 1408 14 IOA21D1BWP7T $T=232960 183120 0 180 $X=229310 $Y=178910
X3809 1482 1450 704 8 411 14 IOA21D1BWP7T $T=240240 167440 0 180 $X=236590 $Y=163230
X3810 1507 1475 1482 8 413 14 IOA21D1BWP7T $T=247520 167440 0 180 $X=243870 $Y=163230
X3811 1530 1490 1507 8 1512 14 IOA21D1BWP7T $T=251440 167440 1 180 $X=247790 $Y=167205
X3812 1566 1497 1530 8 1541 14 IOA21D1BWP7T $T=256480 175280 1 180 $X=252830 $Y=175045
X3813 1625 1609 1591 8 634 14 IOA21D1BWP7T $T=266000 190960 0 180 $X=262350 $Y=186750
X3814 1646 688 1663 8 725 14 IOA21D1BWP7T $T=269920 198800 1 0 $X=269630 $Y=194590
X3815 1717 757 1681 8 611 14 IOA21D1BWP7T $T=281120 183120 1 180 $X=277470 $Y=182885
X3816 430 516 431 8 95 14 IOA21D1BWP7T $T=282240 206640 1 0 $X=281950 $Y=202430
X3817 526 2049 1902 8 628 14 IOA21D1BWP7T $T=351120 261520 1 180 $X=347470 $Y=261285
X3818 input_select_dbg 867 2081 8 checker_in 14 IOA21D1BWP7T $T=355600 230160 0 0 $X=355310 $Y=229925
X3819 1678 8 1850 14 CKBD3BWP7T $T=302400 120400 0 0 $X=302110 $Y=120165
X3820 1850 8 94 14 CKBD3BWP7T $T=358960 175280 0 180 $X=354190 $Y=171070
X3821 232 618 14 8 916 938 ICV_110 $T=148960 355600 1 180 $X=137470 $Y=355365
X3822 234 485 14 8 972 750 ICV_110 $T=169120 167440 0 180 $X=157630 $Y=163230
X3823 234 619 14 8 1138 1057 ICV_110 $T=180320 245840 1 180 $X=168830 $Y=245605
X3824 232 620 14 8 1229 1109 ICV_110 $T=197120 339920 1 180 $X=185630 $Y=339685
X3825 223 621 14 8 1228 1220 ICV_110 $T=206640 277200 0 180 $X=195150 $Y=272990
X3826 92 622 14 8 1314 1353 ICV_110 $T=236320 253680 1 180 $X=224830 $Y=253445
X3827 283 623 14 8 1555 1769 ICV_110 $T=319200 316400 0 180 $X=307710 $Y=312190
X3828 139 624 14 8 2072 2070 ICV_110 $T=365120 159600 0 180 $X=353630 $Y=155390
X3829 265 625 14 8 2067 2038 ICV_110 $T=365120 277200 0 180 $X=353630 $Y=272990
X3830 1038 200 750 1049 613 8 1047 14 AOI221D0BWP7T $T=160720 206640 1 0 $X=160430 $Y=202430
X3831 1072 200 945 1068 613 8 1077 14 AOI221D0BWP7T $T=170800 206640 1 180 $X=166030 $Y=206405
X3832 1095 200 754 1076 613 8 1090 14 AOI221D0BWP7T $T=171920 198800 1 180 $X=167150 $Y=198565
X3833 1104 200 506 1097 613 8 1091 14 AOI221D0BWP7T $T=173040 206640 0 180 $X=168270 $Y=202430
X3834 1116 200 748 1124 613 8 1125 14 AOI221D0BWP7T $T=174160 206640 0 0 $X=173870 $Y=206405
X3835 1169 200 755 1143 613 8 1106 14 AOI221D0BWP7T $T=181440 198800 1 180 $X=176670 $Y=198565
X3836 1187 200 395 1141 613 8 1137 14 AOI221D0BWP7T $T=182000 206640 0 180 $X=177230 $Y=202430
X3837 1201 200 405 1184 613 8 1189 14 AOI221D0BWP7T $T=190960 190960 0 180 $X=186190 $Y=186750
X3838 1290 200 510 1277 613 8 1212 14 AOI221D0BWP7T $T=210000 175280 0 180 $X=205230 $Y=171070
X3839 1270 200 401 1342 613 8 1288 14 AOI221D0BWP7T $T=217280 183120 0 0 $X=216990 $Y=182885
X3840 1771 200 1405 1604 627 8 1752 14 AOI221D0BWP7T $T=288400 269360 0 180 $X=283630 $Y=265150
X3841 1809 200 1497 1704 627 8 1810 14 AOI221D0BWP7T $T=302400 269360 0 180 $X=297630 $Y=265150
X3842 1846 612 1312 1806 610 8 690 14 AOI221D0BWP7T $T=304080 190960 0 180 $X=299310 $Y=186750
X3843 1823 610 1818 1836 1642 8 1830 14 AOI221D0BWP7T $T=300160 222320 1 0 $X=299870 $Y=218110
X3844 1800 200 730 1841 614 8 1838 14 AOI221D0BWP7T $T=300720 261520 1 0 $X=300430 $Y=257310
X3845 1870 200 1667 732 627 8 693 14 AOI221D0BWP7T $T=310240 269360 0 180 $X=305470 $Y=265150
X3846 1884 200 757 1815 627 8 719 14 AOI221D0BWP7T $T=314160 261520 1 180 $X=309390 $Y=261285
X3847 1911 200 1750 1808 627 8 695 14 AOI221D0BWP7T $T=320880 261520 0 180 $X=316110 $Y=257310
X3848 1938 610 580 1924 613 8 1877 14 AOI221D0BWP7T $T=324800 190960 0 180 $X=320030 $Y=186750
X3849 1901 200 430 1906 613 8 699 14 AOI221D0BWP7T $T=320320 230160 1 0 $X=320030 $Y=225950
X3850 1963 610 1951 1957 613 8 1919 14 AOI221D0BWP7T $T=334880 198800 0 180 $X=330110 $Y=194590
X3851 1990 610 2011 2001 613 8 1958 14 AOI221D0BWP7T $T=339360 198800 1 0 $X=339070 $Y=194590
X3852 2041 120 2062 2050 609 8 2004 14 AOI221D0BWP7T $T=347760 292880 1 0 $X=347470 $Y=288670
X3853 629 120 2071 1837 114 8 1966 14 AOI221D0BWP7T $T=358400 245840 1 180 $X=353630 $Y=245605
X3854 848 626 578 850 8 14 AOI21D0BWP7T $T=114800 214480 0 0 $X=114510 $Y=214245
X3855 1553 627 628 721 8 14 AOI21D0BWP7T $T=337120 261520 0 0 $X=336830 $Y=261285
X3856 2039 114 629 2061 8 14 AOI21D0BWP7T $T=353920 238000 0 0 $X=353630 $Y=237765
X3903 1754 630 8 1745 14 CKND2D1BWP7T $T=287840 285040 0 180 $X=285310 $Y=280830
X3904 1754 100 8 1631 14 CKND2D1BWP7T $T=300720 285040 0 180 $X=298190 $Y=280830
X3905 1754 631 8 1725 14 CKND2D1BWP7T $T=299600 285040 0 0 $X=299310 $Y=284805
X3906 2022 519 8 617 14 CKND2D1BWP7T $T=350560 143920 1 0 $X=350270 $Y=139710
X3907 158 793 591 8 825 14 AN3D1BWP7T $T=105840 238000 1 0 $X=105550 $Y=233790
X3908 924 948 949 8 999 14 AN3D1BWP7T $T=147280 269360 1 0 $X=146990 $Y=265150
X3909 196 592 234 8 1025 14 AN3D1BWP7T $T=150080 222320 0 0 $X=149790 $Y=222085
X3910 196 668 234 8 1033 14 AN3D1BWP7T $T=151200 214480 0 0 $X=150910 $Y=214245
X3911 196 793 234 8 1021 14 AN3D1BWP7T $T=151200 230160 1 0 $X=150910 $Y=225950
X3912 196 665 234 8 1036 14 AN3D1BWP7T $T=157920 238000 0 0 $X=157630 $Y=237765
X3913 196 586 234 8 1050 14 AN3D1BWP7T $T=165760 245840 1 180 $X=162110 $Y=245605
X3914 991 1040 1023 8 1083 14 AN3D1BWP7T $T=162960 332080 0 0 $X=162670 $Y=331845
X3915 196 394 234 8 1177 14 AN3D1BWP7T $T=189280 214480 1 180 $X=185630 $Y=214245
X3916 196 581 234 8 1185 14 AN3D1BWP7T $T=190400 245840 1 180 $X=186750 $Y=245605
X3917 196 584 234 8 1239 14 AN3D1BWP7T $T=192640 222320 1 0 $X=192350 $Y=218110
X3918 196 594 234 8 1250 14 AN3D1BWP7T $T=198240 222320 1 0 $X=197950 $Y=218110
X3919 196 587 234 8 1216 14 AN3D1BWP7T $T=202720 230160 1 180 $X=199070 $Y=229925
X3920 196 399 234 8 1273 14 AN3D1BWP7T $T=201040 206640 0 0 $X=200750 $Y=206405
X3921 196 398 234 8 1249 14 AN3D1BWP7T $T=204960 214480 1 180 $X=201310 $Y=214245
X3922 196 591 234 8 1259 14 AN3D1BWP7T $T=206080 230160 1 180 $X=202430 $Y=229925
X3923 194 591 234 8 1247 14 AN3D1BWP7T $T=206640 238000 0 180 $X=202990 $Y=233790
X3924 1262 590 1243 8 1293 14 AN3D1BWP7T $T=203280 363440 1 0 $X=202990 $Y=359230
X3925 194 587 92 8 1278 14 AN3D1BWP7T $T=206080 230160 0 0 $X=205790 $Y=229925
X3926 194 581 92 8 1248 14 AN3D1BWP7T $T=209440 245840 0 180 $X=205790 $Y=241630
X3927 196 593 234 8 1291 14 AN3D1BWP7T $T=207200 206640 0 0 $X=206910 $Y=206405
X3928 196 664 234 8 1339 14 AN3D1BWP7T $T=216160 206640 0 0 $X=215870 $Y=206405
X3929 194 594 92 8 1355 14 AN3D1BWP7T $T=218400 214480 0 0 $X=218110 $Y=214245
X3930 196 595 92 8 1338 14 AN3D1BWP7T $T=225120 206640 1 180 $X=221470 $Y=206405
X3931 1386 1328 1351 8 1407 14 AN3D1BWP7T $T=226800 269360 0 0 $X=226510 $Y=269125
X3932 196 410 92 8 1409 14 AN3D1BWP7T $T=227360 206640 0 0 $X=227070 $Y=206405
X3933 1457 1419 1425 8 65 14 AN3D1BWP7T $T=236320 159600 0 180 $X=232670 $Y=155390
X3934 194 410 92 8 1443 14 AN3D1BWP7T $T=240240 206640 1 180 $X=236590 $Y=206405
X3935 196 408 92 8 1495 14 AN3D1BWP7T $T=243600 206640 0 0 $X=243310 $Y=206405
X3936 194 408 92 8 1491 14 AN3D1BWP7T $T=243600 214480 1 0 $X=243310 $Y=210270
X3937 194 596 92 8 1528 14 AN3D1BWP7T $T=249200 214480 1 0 $X=248910 $Y=210270
X3938 194 597 92 8 1585 14 AN3D1BWP7T $T=256480 214480 0 0 $X=256190 $Y=214245
X3939 196 596 92 8 1596 14 AN3D1BWP7T $T=259280 206640 0 0 $X=258990 $Y=206405
X3940 196 419 92 8 1661 14 AN3D1BWP7T $T=277200 222320 1 180 $X=273550 $Y=222085
X3941 196 677 92 8 1751 14 AN3D1BWP7T $T=295120 230160 1 180 $X=291470 $Y=229925
X3942 194 677 92 8 1782 14 AN3D1BWP7T $T=292320 222320 0 0 $X=292030 $Y=222085
X3943 194 422 92 8 1813 14 AN3D1BWP7T $T=301840 253680 0 180 $X=298190 $Y=249470
X3944 194 1312 139 8 1831 14 AN3D1BWP7T $T=299600 198800 0 0 $X=299310 $Y=198565
X3945 194 636 139 8 1835 14 AN3D1BWP7T $T=299600 214480 1 0 $X=299310 $Y=210270
X3946 194 1719 139 8 1844 14 AN3D1BWP7T $T=300160 238000 1 0 $X=299870 $Y=233790
X3947 194 424 92 8 1855 14 AN3D1BWP7T $T=300720 245840 0 0 $X=300430 $Y=245605
X3948 194 688 92 8 1866 14 AN3D1BWP7T $T=304080 253680 1 0 $X=303790 $Y=249470
X3949 196 422 139 8 1894 14 AN3D1BWP7T $T=312480 206640 0 0 $X=312190 $Y=206405
X3950 196 424 139 8 1898 14 AN3D1BWP7T $T=312480 214480 1 0 $X=312190 $Y=210270
X3951 196 688 139 8 1937 14 AN3D1BWP7T $T=315840 214480 0 0 $X=315550 $Y=214245
X3952 196 busy 265 8 2048 14 AN3D1BWP7T $T=348320 300720 1 0 $X=348030 $Y=296510
X3977 947 632 633 919 8 882 14 OAI211D1BWP7T $T=136640 222320 0 180 $X=132990 $Y=218110
X3978 1463 634 635 1505 8 855 14 OAI211D1BWP7T $T=244160 190960 1 0 $X=243870 $Y=186750
X3979 785 523 636 1580 8 1582 14 OAI211D1BWP7T $T=255920 190960 0 0 $X=255630 $Y=190725
X3980 1729 637 638 1753 8 683 14 OAI211D1BWP7T $T=282240 198800 0 0 $X=281950 $Y=198565
X3981 191 639 640 1764 8 637 14 OAI211D1BWP7T $T=285600 206640 1 0 $X=285310 $Y=202430
X3982 1902 641 642 198 8 1901 14 OAI211D1BWP7T $T=318640 238000 0 180 $X=314990 $Y=233790
X3983 2061 643 644 2037 8 2041 14 OAI211D1BWP7T $T=350560 285040 0 180 $X=346910 $Y=280830
X3984 14 8 904 371 630 ICV_117 $T=124880 308560 1 180 $X=121790 $Y=308325
X3985 14 8 977 373 630 ICV_117 $T=146720 277200 1 180 $X=143630 $Y=276965
X3986 14 8 979 242 630 ICV_117 $T=150640 261520 1 180 $X=147550 $Y=261285
X3987 14 8 1352 375 631 ICV_117 $T=221200 261520 1 180 $X=218110 $Y=261285
X3988 14 8 1465 458 631 ICV_117 $T=236880 316400 0 180 $X=233790 $Y=312190
X3989 14 8 1449 386 1214 ICV_117 $T=238000 363440 1 180 $X=234910 $Y=363205
X3990 14 8 1563 287 796 ICV_117 $T=255920 238000 0 180 $X=252830 $Y=233790
X3991 14 8 1763 302 1214 ICV_117 $T=286720 371280 1 180 $X=283630 $Y=371045
X3992 14 8 1776 770 1214 ICV_117 $T=289520 355600 1 180 $X=286430 $Y=355365
X3993 14 8 1889 313 1214 ICV_117 $T=315280 379120 0 180 $X=312190 $Y=374910
X3994 14 8 1712 551 100 ICV_117 $T=334320 222320 1 180 $X=331230 $Y=222085
X3995 14 8 2022 103 519 ICV_117 $T=346640 136080 1 180 $X=343550 $Y=135845
X3996 14 8 inject_error_enable_dbg 338 100 ICV_117 $T=348880 316400 0 180 $X=345790 $Y=312190
X3997 608 14 8 997 1015 610 996 ICV_118 $T=154560 253680 1 180 $X=150910 $Y=253445
X3998 608 14 8 981 1035 610 1019 ICV_118 $T=161280 300720 1 180 $X=157630 $Y=300485
X3999 200 14 8 404 1112 613 1088 ICV_118 $T=174720 159600 1 180 $X=171070 $Y=159365
X4000 609 14 8 1619 680 1071 1599 ICV_118 $T=266000 339920 1 180 $X=262350 $Y=339685
X4001 609 14 8 729 692 1071 1801 ICV_118 $T=303520 332080 0 180 $X=299870 $Y=327870
X4002 200 14 8 516 1961 1046 1869 ICV_118 $T=322000 206640 1 180 $X=318350 $Y=206405
X4003 608 14 8 2024 724 1642 1989 ICV_118 $T=343840 238000 1 180 $X=340190 $Y=237765
X4004 610 14 8 2053 723 1999 1978 ICV_118 $T=348880 238000 0 180 $X=345230 $Y=233790
X4005 888 581 586 871 31 8 14 IND4D0BWP7T $T=123760 253680 0 180 $X=119550 $Y=249470
X4006 1344 1258 645 1323 753 8 14 IND4D0BWP7T $T=219520 386960 0 180 $X=215310 $Y=382750
X4007 401 1100 174 1348 1349 8 14 IND4D0BWP7T $T=217840 183120 1 0 $X=217550 $Y=178910
X4008 1607 1511 646 437 1612 8 14 IND4D0BWP7T $T=264880 112560 1 0 $X=264590 $Y=108350
X4009 2020 2031 647 2066 2045 8 14 IND4D0BWP7T $T=344400 261520 1 0 $X=344110 $Y=257310
X4010 665 592 595 594 8 888 14 ND4D0BWP7T $T=142240 253680 1 180 $X=138590 $Y=253445
X4011 1010 648 649 1047 8 1059 14 ND4D0BWP7T $T=160160 277200 1 0 $X=159870 $Y=272990
X4012 990 650 651 1090 8 1098 14 ND4D0BWP7T $T=168000 292880 0 0 $X=167710 $Y=292645
X4013 1004 652 653 1091 8 1120 14 ND4D0BWP7T $T=171360 261520 0 0 $X=171070 $Y=261285
X4014 1015 654 655 1137 8 1162 14 ND4D0BWP7T $T=178080 253680 0 0 $X=177790 $Y=253445
X4015 1181 656 657 1179 8 1142 14 ND4D0BWP7T $T=189280 285040 1 180 $X=185630 $Y=284805
X4016 1008 658 659 1189 8 1170 14 ND4D0BWP7T $T=190960 253680 1 180 $X=187310 $Y=253445
X4017 992 660 661 1212 8 1195 14 ND4D0BWP7T $T=190400 269360 0 0 $X=190110 $Y=269125
X4018 1016 662 663 1217 8 1222 14 ND4D0BWP7T $T=192640 261520 0 0 $X=192350 $Y=261285
X4019 408 586 664 793 8 1271 14 ND4D0BWP7T $T=199920 245840 1 0 $X=199630 $Y=241630
X4020 596 665 584 398 8 1253 14 ND4D0BWP7T $T=204960 238000 1 180 $X=201310 $Y=237765
X4021 1260 666 667 1272 8 1276 14 ND4D0BWP7T $T=203280 300720 1 0 $X=202990 $Y=296510
X4022 1312 592 668 587 8 1295 14 ND4D0BWP7T $T=212800 230160 1 180 $X=209150 $Y=229925
X4023 597 581 410 399 8 1321 14 ND4D0BWP7T $T=218960 238000 0 180 $X=215310 $Y=233790
X4024 585 669 670 1316 8 1344 14 ND4D0BWP7T $T=219520 371280 1 0 $X=219230 $Y=367070
X4025 1479 671 672 1426 8 1421 14 ND4D0BWP7T $T=236880 355600 0 180 $X=233230 $Y=351390
X4026 1467 673 674 1447 8 1464 14 ND4D0BWP7T $T=240240 308560 0 180 $X=236590 $Y=304350
X4027 1517 675 676 1489 8 1538 14 ND4D0BWP7T $T=252000 277200 1 180 $X=248350 $Y=276965
X4028 636 594 677 595 8 1524 14 ND4D0BWP7T $T=254800 214480 1 180 $X=251150 $Y=214245
X4029 1615 678 679 1601 8 1598 14 ND4D0BWP7T $T=266000 292880 1 180 $X=262350 $Y=292645
X4030 1645 680 681 1594 8 1626 14 ND4D0BWP7T $T=266000 300720 0 180 $X=262350 $Y=296510
X4031 640 422 424 419 8 1350 14 ND4D0BWP7T $T=274960 238000 0 180 $X=271310 $Y=233790
X4032 1703 682 683 1670 8 1609 14 ND4D0BWP7T $T=277760 190960 1 180 $X=274110 $Y=190725
X4033 1711 684 685 1680 8 1691 14 ND4D0BWP7T $T=280000 300720 1 180 $X=276350 $Y=300485
X4034 1752 686 687 1775 8 1780 14 ND4D0BWP7T $T=288400 285040 0 0 $X=288110 $Y=284805
X4035 1719 432 688 1712 8 1513 14 ND4D0BWP7T $T=295120 222320 0 180 $X=291470 $Y=218110
X4036 1774 689 690 1810 8 1772 14 ND4D0BWP7T $T=298480 308560 1 0 $X=298190 $Y=304350
X4037 1838 691 692 1830 8 1819 14 ND4D0BWP7T $T=303520 292880 0 180 $X=299870 $Y=288670
X4038 1851 693 694 1877 8 1873 14 ND4D0BWP7T $T=309680 269360 0 0 $X=309390 $Y=269125
X4039 1926 695 696 1958 8 1955 14 ND4D0BWP7T $T=330960 261520 0 0 $X=330670 $Y=261285
X4040 101 104 697 cfg_re_dbg 8 2000 14 ND4D0BWP7T $T=344400 128240 1 180 $X=340750 $Y=128005
X4041 2034 698 699 2004 8 1986 14 ND4D0BWP7T $T=344400 245840 1 180 $X=340750 $Y=245605
X4042 2028 700 701 1940 8 2012 14 ND4D0BWP7T $T=346080 253680 0 180 $X=342430 $Y=249470
X4043 1907 702 703 2016 8 2014 14 ND4D0BWP7T $T=347200 222320 1 180 $X=343550 $Y=222085
X4044 1111 185 524 1032 1044 8 14 MOAI22D0BWP7T $T=165200 285040 1 180 $X=160990 $Y=284805
X4045 1046 1052 201 1064 1072 8 14 MOAI22D0BWP7T $T=161840 214480 0 0 $X=161550 $Y=214245
X4046 1060 185 524 1045 1053 8 14 MOAI22D0BWP7T $T=165760 261520 1 180 $X=161550 $Y=261285
X4047 1046 1057 201 1066 1038 8 14 MOAI22D0BWP7T $T=162960 238000 1 0 $X=162670 $Y=233790
X4048 1059 185 524 1081 1043 8 14 MOAI22D0BWP7T $T=165200 269360 0 0 $X=164910 $Y=269125
X4049 1046 1084 201 1063 1095 8 14 MOAI22D0BWP7T $T=173600 214480 0 180 $X=169390 $Y=210270
X4050 1046 1074 201 1065 1116 8 14 MOAI22D0BWP7T $T=171360 238000 1 0 $X=171070 $Y=233790
X4051 1142 185 524 1080 1108 8 14 MOAI22D0BWP7T $T=176400 277200 1 180 $X=172190 $Y=276965
X4052 1046 1093 201 1078 1104 8 14 MOAI22D0BWP7T $T=173040 230160 1 0 $X=172750 $Y=225950
X4053 1156 185 524 1133 1117 8 14 MOAI22D0BWP7T $T=181440 300720 0 180 $X=177230 $Y=296510
X4054 1129 185 524 1134 1094 8 14 MOAI22D0BWP7T $T=181440 300720 1 180 $X=177230 $Y=300485
X4055 1162 185 524 1079 1144 8 14 MOAI22D0BWP7T $T=182560 253680 0 180 $X=178350 $Y=249470
X4056 1147 185 524 1166 1119 8 14 MOAI22D0BWP7T $T=179760 277200 0 0 $X=179470 $Y=276965
X4057 1195 185 524 1165 1115 8 14 MOAI22D0BWP7T $T=189840 277200 0 180 $X=185630 $Y=272990
X4058 1046 1188 201 1199 1169 8 14 MOAI22D0BWP7T $T=187040 206640 0 0 $X=186750 $Y=206405
X4059 1046 1207 201 1190 1187 8 14 MOAI22D0BWP7T $T=192080 198800 1 180 $X=187870 $Y=198565
X4060 1221 185 524 1191 1197 8 14 MOAI22D0BWP7T $T=192640 300720 0 180 $X=188430 $Y=296510
X4061 1046 1204 201 1226 1201 8 14 MOAI22D0BWP7T $T=190960 190960 1 0 $X=190670 $Y=186750
X4062 1276 185 524 1227 1235 8 14 MOAI22D0BWP7T $T=199920 300720 0 180 $X=195710 $Y=296510
X4063 1046 1279 201 1256 1270 8 14 MOAI22D0BWP7T $T=208320 183120 1 180 $X=204110 $Y=182885
X4064 1046 1304 201 1280 1290 8 14 MOAI22D0BWP7T $T=212240 198800 0 180 $X=208030 $Y=194590
X4065 1046 1370 201 1379 1330 8 14 MOAI22D0BWP7T $T=224560 190960 1 0 $X=224270 $Y=186750
X4066 1046 1393 201 1375 1319 8 14 MOAI22D0BWP7T $T=229040 190960 1 180 $X=224830 $Y=190725
X4067 704 57 704 57 1374 8 14 MOAI22D0BWP7T $T=230720 167440 0 180 $X=226510 $Y=163230
X4068 1464 185 524 1476 1485 8 14 MOAI22D0BWP7T $T=247520 277200 1 180 $X=243310 $Y=276965
X4069 1538 185 524 1572 1550 8 14 MOAI22D0BWP7T $T=254240 277200 0 0 $X=253950 $Y=276965
X4070 1598 185 524 1633 1624 8 14 MOAI22D0BWP7T $T=263760 285040 1 0 $X=263470 $Y=280830
X4071 1642 1636 198 1614 1602 8 14 MOAI22D0BWP7T $T=268800 206640 1 180 $X=264590 $Y=206405
X4072 1626 185 524 1684 1683 8 14 MOAI22D0BWP7T $T=270480 292880 1 0 $X=270190 $Y=288670
X4073 1046 1676 201 1694 1692 8 14 MOAI22D0BWP7T $T=273840 206640 1 0 $X=273550 $Y=202430
X4074 1691 185 524 1722 1755 8 14 MOAI22D0BWP7T $T=285040 292880 0 0 $X=284750 $Y=292645
X4075 1780 185 524 1805 1792 8 14 MOAI22D0BWP7T $T=291200 292880 1 0 $X=290910 $Y=288670
X4076 1819 185 524 1842 1839 8 14 MOAI22D0BWP7T $T=299600 292880 0 0 $X=299310 $Y=292645
X4077 613 1807 198 1849 1823 8 14 MOAI22D0BWP7T $T=300160 206640 1 0 $X=299870 $Y=202430
X4078 613 1833 198 1862 1846 8 14 MOAI22D0BWP7T $T=301280 183120 0 0 $X=300990 $Y=182885
X4079 1873 185 524 1854 1856 8 14 MOAI22D0BWP7T $T=309680 285040 1 180 $X=305470 $Y=284805
X4080 1955 185 524 1947 1950 8 14 MOAI22D0BWP7T $T=333760 292880 0 180 $X=329550 $Y=288670
X4081 608 1984 201 1968 1938 8 14 MOAI22D0BWP7T $T=338800 198800 0 180 $X=334590 $Y=194590
X4082 608 2002 201 1972 1963 8 14 MOAI22D0BWP7T $T=342160 206640 0 180 $X=337950 $Y=202430
X4083 608 2006 201 1973 1990 8 14 MOAI22D0BWP7T $T=342720 214480 0 180 $X=338510 $Y=210270
X4084 1980 185 524 2025 1952 8 14 MOAI22D0BWP7T $T=339920 285040 1 0 $X=339630 $Y=280830
X4085 2045 185 524 2013 1954 8 14 MOAI22D0BWP7T $T=346640 269360 1 180 $X=342430 $Y=269125
X4086 2012 185 524 1992 1977 8 14 MOAI22D0BWP7T $T=347200 277200 0 180 $X=342990 $Y=272990
X4087 busy 427 591 8 1508 14 ND3D0BWP7T $T=245840 222320 0 0 $X=245550 $Y=222085
X4088 640 1764 639 8 1729 14 ND3D0BWP7T $T=291760 206640 0 180 $X=288670 $Y=202430
X4089 1939 1966 1969 8 1974 14 ND3D0BWP7T $T=333760 245840 0 0 $X=333470 $Y=245605
X4090 101 107 2026 8 1962 14 ND3D0BWP7T $T=343280 151760 0 0 $X=342990 $Y=151525
X4091 bit_error 614 1971 1974 8 1980 14 AO211D0BWP7T $T=333200 245840 1 0 $X=332910 $Y=241630
X4092 bit_error 598 2014 2008 8 2021 14 AO211D0BWP7T $T=341600 300720 1 0 $X=341310 $Y=296510
X4093 1030 1033 8 1063 14 DFD1BWP7T $T=157920 214480 1 0 $X=157630 $Y=210270
X4094 1030 1036 8 1065 14 DFD1BWP7T $T=157920 230160 0 0 $X=157630 $Y=229925
X4095 1030 1025 8 1064 14 DFD1BWP7T $T=159600 222320 0 0 $X=159310 $Y=222085
X4096 1030 1021 8 1078 14 DFD1BWP7T $T=159600 230160 1 0 $X=159310 $Y=225950
X4097 1030 1050 8 1066 14 DFD1BWP7T $T=160720 245840 1 0 $X=160430 $Y=241630
X4098 1030 1177 8 1190 14 DFD1BWP7T $T=185920 222320 0 0 $X=185630 $Y=222085
X4099 1030 1216 8 735 14 DFD1BWP7T $T=197120 230160 0 180 $X=185630 $Y=225950
X4100 1030 1185 8 736 14 DFD1BWP7T $T=185920 245840 1 0 $X=185630 $Y=241630
X4101 1245 1239 8 1199 14 DFD1BWP7T $T=200480 214480 1 180 $X=188990 $Y=214245
X4102 1030 1259 8 734 14 DFD1BWP7T $T=208320 230160 0 180 $X=196830 $Y=225950
X4103 1245 1249 8 1280 14 DFD1BWP7T $T=198240 214480 1 0 $X=197950 $Y=210270
X4104 1245 1273 8 1226 14 DFD1BWP7T $T=211120 198800 1 180 $X=199630 $Y=198565
X4105 1245 1291 8 1256 14 DFD1BWP7T $T=212240 206640 0 180 $X=200750 $Y=202430
X4106 1245 1250 8 737 14 DFD1BWP7T $T=201600 222320 1 0 $X=201310 $Y=218110
X4107 1245 1338 8 1375 14 DFD1BWP7T $T=216160 198800 0 0 $X=215870 $Y=198565
X4108 1245 1339 8 1379 14 DFD1BWP7T $T=216160 206640 1 0 $X=215870 $Y=202430
X4109 1245 1409 8 738 14 DFD1BWP7T $T=229600 198800 0 0 $X=229310 $Y=198565
X4110 1245 1495 8 740 14 DFD1BWP7T $T=243600 198800 1 0 $X=243310 $Y=194590
X4111 1583 1596 8 742 14 DFD1BWP7T $T=268240 198800 1 180 $X=256750 $Y=198565
X4112 1583 1661 8 1694 14 DFD1BWP7T $T=269920 222320 1 0 $X=269630 $Y=218110
X4113 1583 1751 8 743 14 DFD1BWP7T $T=283920 230160 1 0 $X=283630 $Y=225950
X4114 1878 1894 8 1968 14 DFD1BWP7T $T=325920 198800 0 0 $X=325630 $Y=198565
X4115 1878 1898 8 1972 14 DFD1BWP7T $T=325920 206640 1 0 $X=325630 $Y=202430
X4116 1878 1937 8 1973 14 DFD1BWP7T $T=325920 214480 1 0 $X=325630 $Y=210270
X4117 2067 2048 8 644 14 DFD1BWP7T $T=352800 285040 1 180 $X=341310 $Y=284805
X4137 822 917 236 8 959 14 DFCNQD1BWP7T $T=129920 120400 1 0 $X=129630 $Y=116190
X4138 822 169 236 8 917 14 DFCNQD1BWP7T $T=129920 120400 0 0 $X=129630 $Y=120165
X4139 953 957 236 8 235 14 DFCNQD1BWP7T $T=140560 136080 1 0 $X=140270 $Y=131870
X4140 953 963 236 8 537 14 DFCNQD1BWP7T $T=140560 136080 0 0 $X=140270 $Y=135845
X4141 971 976 236 8 1013 14 DFCNQD1BWP7T $T=143360 112560 0 0 $X=143070 $Y=112325
X4142 971 978 236 8 1014 14 DFCNQD1BWP7T $T=143360 128240 0 0 $X=143070 $Y=128005
X4143 971 1007 236 8 957 14 DFCNQD1BWP7T $T=156800 120400 0 180 $X=144190 $Y=116190
X4144 971 1037 236 8 1067 14 DFCNQD1BWP7T $T=157920 120400 0 0 $X=157630 $Y=120165
X4145 953 1013 236 8 240 14 DFCNQD1BWP7T $T=157920 136080 1 0 $X=157630 $Y=131870
X4146 953 1014 236 8 485 14 DFCNQD1BWP7T $T=157920 136080 0 0 $X=157630 $Y=135845
X4147 953 1067 236 8 239 14 DFCNQD1BWP7T $T=170240 143920 0 180 $X=157630 $Y=139710
X4148 971 1096 236 8 1158 14 DFCNQD1BWP7T $T=168560 112560 1 0 $X=168270 $Y=108350
X4149 971 1140 236 8 963 14 DFCNQD1BWP7T $T=181440 112560 1 180 $X=168830 $Y=112325
X4150 1159 1149 236 8 249 14 DFCNQD1BWP7T $T=182560 143920 1 180 $X=169950 $Y=143685
X4151 971 1114 236 8 1149 14 DFCNQD1BWP7T $T=170800 120400 0 0 $X=170510 $Y=120165
X4152 953 1158 236 8 237 14 DFCNQD1BWP7T $T=184240 136080 0 180 $X=171630 $Y=131870
X4153 953 1153 236 8 248 14 DFCNQD1BWP7T $T=184240 136080 1 180 $X=171630 $Y=135845
X4154 1159 1154 236 8 250 14 DFCNQD1BWP7T $T=184240 143920 0 180 $X=171630 $Y=139710
X4155 1238 1213 236 8 1154 14 DFCNQD1BWP7T $T=198240 112560 1 180 $X=185630 $Y=112325
X4156 971 1192 236 8 1153 14 DFCNQD1BWP7T $T=198240 120400 1 180 $X=185630 $Y=120165
X4157 1159 1224 236 8 261 14 DFCNQD1BWP7T $T=198240 128240 0 180 $X=185630 $Y=124030
X4158 1159 1225 236 8 745 14 DFCNQD1BWP7T $T=198240 151760 0 180 $X=185630 $Y=147550
X4159 1159 1230 236 8 262 14 DFCNQD1BWP7T $T=198800 136080 0 180 $X=186190 $Y=131870
X4160 1238 1233 236 8 1182 14 DFCNQD1BWP7T $T=199360 112560 0 180 $X=186750 $Y=108350
X4161 971 1146 236 8 1224 14 DFCNQD1BWP7T $T=187600 104720 0 0 $X=187310 $Y=104485
X4162 1159 1182 236 8 255 14 DFCNQD1BWP7T $T=200480 143920 0 180 $X=187870 $Y=139710
X4163 971 1193 236 8 1225 14 DFCNQD1BWP7T $T=198240 128240 1 0 $X=197950 $Y=124030
X4164 1159 1287 236 8 266 14 DFCNQD1BWP7T $T=211120 136080 0 180 $X=198510 $Y=131870
X4165 1238 1289 236 8 1230 14 DFCNQD1BWP7T $T=211680 120400 1 180 $X=199070 $Y=120165
X4166 1238 1274 236 8 1246 14 DFCNQD1BWP7T $T=212240 112560 1 180 $X=199630 $Y=112325
X4167 67 1261 236 8 1369 14 DFCNQD1BWP7T $T=200480 96880 0 0 $X=200190 $Y=96645
X4168 1159 1246 236 8 260 14 DFCNQD1BWP7T $T=200480 136080 0 0 $X=200190 $Y=135845
X4169 1238 1285 73 8 1362 14 DFCNQD1BWP7T $T=215040 120400 0 0 $X=214750 $Y=120165
X4170 1238 1373 73 8 1287 14 DFCNQD1BWP7T $T=227360 128240 0 180 $X=214750 $Y=124030
X4171 67 1369 73 8 1320 14 DFCNQD1BWP7T $T=227920 112560 0 180 $X=215310 $Y=108350
X4172 1392 1362 73 8 270 14 DFCNQD1BWP7T $T=228480 128240 1 180 $X=215870 $Y=128005
X4173 1238 1340 73 8 1445 14 DFCNQD1BWP7T $T=224000 112560 0 0 $X=223710 $Y=112325
X4174 1238 1341 73 8 1433 14 DFCNQD1BWP7T $T=224000 120400 1 0 $X=223710 $Y=116190
X4175 1392 1397 73 8 542 14 DFCNQD1BWP7T $T=227360 136080 1 0 $X=227070 $Y=131870
X4176 67 959 73 8 1469 14 DFCNQD1BWP7T $T=228480 112560 1 0 $X=228190 $Y=108350
X4177 1238 1434 73 8 1397 14 DFCNQD1BWP7T $T=240800 120400 1 180 $X=228190 $Y=120165
X4178 1238 1456 73 8 1558 14 DFCNQD1BWP7T $T=241920 120400 0 0 $X=241630 $Y=120165
X4179 1543 1533 73 8 1452 14 DFCNQD1BWP7T $T=254240 136080 0 180 $X=241630 $Y=131870
X4180 1392 1452 73 8 460 14 DFCNQD1BWP7T $T=241920 136080 0 0 $X=241630 $Y=135845
X4181 1477 1486 73 8 513 14 DFCNQD1BWP7T $T=242480 96880 1 0 $X=242190 $Y=92670
X4182 1543 1542 73 8 1481 14 DFCNQD1BWP7T $T=256480 128240 0 180 $X=243870 $Y=124030
X4183 1477 1562 73 8 512 14 DFCNQD1BWP7T $T=257600 96880 1 180 $X=244990 $Y=96645
X4184 1392 1481 73 8 293 14 DFCNQD1BWP7T $T=254240 128240 0 0 $X=253950 $Y=128005
X4185 1477 1575 73 8 1592 14 DFCNQD1BWP7T $T=254800 89040 0 0 $X=254510 $Y=88805
X4186 1543 1618 73 8 1554 14 DFCNQD1BWP7T $T=267680 120400 1 180 $X=255070 $Y=120165
X4187 1392 1554 73 8 300 14 DFCNQD1BWP7T $T=255920 136080 0 0 $X=255630 $Y=135845
X4188 1543 1581 73 8 1639 14 DFCNQD1BWP7T $T=256480 120400 1 0 $X=256190 $Y=116190
X4189 1392 1623 73 8 389 14 DFCNQD1BWP7T $T=268800 128240 0 180 $X=256190 $Y=124030
X4190 1723 1710 297 8 1635 14 DFCNQD1BWP7T $T=282240 96880 0 180 $X=269630 $Y=92670
X4191 1392 1558 73 8 388 14 DFCNQD1BWP7T $T=271040 120400 1 0 $X=270750 $Y=116190
X4192 1658 1639 297 8 310 14 DFCNQD1BWP7T $T=272160 128240 1 0 $X=271870 $Y=124030
X4193 1543 1687 73 8 1623 14 DFCNQD1BWP7T $T=273280 112560 1 0 $X=272990 $Y=108350
X4194 1723 1777 297 8 1638 14 DFCNQD1BWP7T $T=296240 89040 1 180 $X=283630 $Y=88805
X4195 1543 1787 297 8 1731 14 DFCNQD1BWP7T $T=296240 104720 0 180 $X=283630 $Y=100510
X4196 1543 1727 297 8 1737 14 DFCNQD1BWP7T $T=296240 112560 1 180 $X=283630 $Y=112325
X4197 1723 1785 297 8 1662 14 DFCNQD1BWP7T $T=296800 96880 1 180 $X=284190 $Y=96645
X4198 1658 1731 297 8 298 14 DFCNQD1BWP7T $T=296800 120400 0 180 $X=284190 $Y=116190
X4199 1658 1737 297 8 308 14 DFCNQD1BWP7T $T=284480 128240 1 0 $X=284190 $Y=124030
X4200 1723 1858 297 8 1781 14 DFCNQD1BWP7T $T=310240 96880 0 180 $X=297630 $Y=92670
X4201 1543 1812 297 8 1832 14 DFCNQD1BWP7T $T=297920 104720 0 0 $X=297630 $Y=104485
X4202 1543 1860 297 8 1617 14 DFCNQD1BWP7T $T=310240 112560 0 180 $X=297630 $Y=108350
X4203 1658 1825 297 8 321 14 DFCNQD1BWP7T $T=297920 143920 1 0 $X=297630 $Y=139710
X4204 1658 1832 297 8 319 14 DFCNQD1BWP7T $T=298480 136080 1 0 $X=298190 $Y=131870
X4205 1868 1865 297 8 1816 14 DFCNQD1BWP7T $T=311360 112560 1 180 $X=298750 $Y=112325
X4206 67 1688 297 8 cfg_we_dbg 14 DFCNQD1BWP7T $T=299600 104720 1 0 $X=299310 $Y=100510
X4207 1658 1816 297 8 314 14 DFCNQD1BWP7T $T=299600 128240 1 0 $X=299310 $Y=124030
X4208 1868 1747 297 8 1825 14 DFCNQD1BWP7T $T=313040 120400 0 180 $X=300430 $Y=116190
X4209 1723 1871 297 8 1908 14 DFCNQD1BWP7T $T=307440 96880 0 0 $X=307150 $Y=96645
X4210 1723 1883 297 8 1896 14 DFCNQD1BWP7T $T=310240 96880 1 0 $X=309950 $Y=92670
X4211 1658 1875 297 8 311 14 DFCNQD1BWP7T $T=310240 143920 1 0 $X=309950 $Y=139710
X4212 1868 1914 297 8 1875 14 DFCNQD1BWP7T $T=323680 112560 1 180 $X=311070 $Y=112325
X4213 1868 1890 297 8 1886 14 DFCNQD1BWP7T $T=311920 112560 1 0 $X=311630 $Y=108350
X4214 1868 1891 297 8 1892 14 DFCNQD1BWP7T $T=311920 128240 1 0 $X=311630 $Y=124030
X4215 1658 1886 139 8 322 14 DFCNQD1BWP7T $T=311920 151760 1 0 $X=311630 $Y=147550
X4216 1658 1892 297 8 382 14 DFCNQD1BWP7T $T=312480 136080 1 0 $X=312190 $Y=131870
X4217 1868 1913 297 8 1982 14 DFCNQD1BWP7T $T=325920 112560 0 0 $X=325630 $Y=112325
X4218 1868 1922 297 8 1932 14 DFCNQD1BWP7T $T=325920 128240 1 0 $X=325630 $Y=124030
X4219 1658 1932 297 8 326 14 DFCNQD1BWP7T $T=325920 136080 1 0 $X=325630 $Y=131870
X4220 1868 1941 297 8 1934 14 DFCNQD1BWP7T $T=326480 112560 1 0 $X=326190 $Y=108350
X4221 1868 1942 297 8 1943 14 DFCNQD1BWP7T $T=326480 120400 0 0 $X=326190 $Y=120165
X4222 1868 1949 297 8 1956 14 DFCNQD1BWP7T $T=327040 104720 0 0 $X=326750 $Y=104485
X4223 1945 1943 297 8 99 14 DFCNQD1BWP7T $T=328160 120400 1 0 $X=327870 $Y=116190
X4224 67 1897 297 8 cfg_re_dbg 14 DFCNQD1BWP7T $T=333200 96880 0 0 $X=332910 $Y=96645
X4225 1945 1982 297 8 519 14 DFCNQD1BWP7T $T=340480 104720 1 0 $X=340190 $Y=100510
X4226 1945 1956 297 8 107 14 DFCNQD1BWP7T $T=340480 104720 0 0 $X=340190 $Y=104485
X4227 1945 1934 297 8 101 14 DFCNQD1BWP7T $T=340480 112560 1 0 $X=340190 $Y=108350
X4228 1945 1433 297 8 2022 14 DFCNQD1BWP7T $T=340480 120400 1 0 $X=340190 $Y=116190
X4229 524 14 8 1098 185 1039 1034 ICV_120 $T=164080 292880 1 180 $X=159870 $Y=292645
X4230 524 14 8 1120 185 1042 1102 ICV_120 $T=176400 253680 0 180 $X=172190 $Y=249470
X4231 524 14 8 1170 185 1089 1105 ICV_120 $T=180880 261520 0 180 $X=176670 $Y=257310
X4232 524 14 8 1222 185 1160 1163 ICV_120 $T=190400 261520 1 180 $X=186190 $Y=261285
X4233 524 14 8 1297 185 1251 1234 ICV_120 $T=204400 253680 0 180 $X=200190 $Y=249470
X4234 524 14 8 1772 185 1660 1740 ICV_120 $T=287840 300720 1 180 $X=283630 $Y=300485
X4235 524 14 8 1920 185 1893 1903 ICV_120 $T=322000 285040 1 180 $X=317790 $Y=284805
X4236 524 14 8 2021 185 1988 1993 ICV_120 $T=343840 292880 0 180 $X=339630 $Y=288670
X4237 705 706 14 8 1005 1069 1060 ICV_121 $T=165760 269360 1 0 $X=165470 $Y=265150
X4238 707 708 14 8 1003 1106 1111 ICV_121 $T=170240 285040 0 0 $X=169950 $Y=284805
X4239 709 710 14 8 1035 1077 1129 ICV_121 $T=171920 300720 0 0 $X=171630 $Y=300485
X4240 711 712 14 8 989 1145 1147 ICV_121 $T=177520 285040 0 0 $X=177230 $Y=284805
X4241 713 714 14 8 1121 1125 1156 ICV_121 $T=178640 308560 0 0 $X=178350 $Y=308325
X4242 715 716 14 8 1208 1244 1221 ICV_121 $T=196560 300720 0 0 $X=196270 $Y=300485
X4243 717 718 14 8 1242 1288 1297 ICV_121 $T=206640 253680 1 0 $X=206350 $Y=249470
X4244 719 720 14 8 1888 1919 1920 ICV_121 $T=319200 261520 0 0 $X=318910 $Y=261285
X4245 721 722 14 8 1909 1996 1971 ICV_121 $T=338240 222320 0 0 $X=337950 $Y=222085
X4246 723 724 14 8 1961 2009 2020 ICV_121 $T=339920 238000 1 0 $X=339630 $Y=233790
X4256 1024 1042 223 8 1079 14 DFCND1BWP7T $T=157920 253680 1 0 $X=157630 $Y=249470
X4257 1031 1043 223 8 1080 14 DFCND1BWP7T $T=157920 277200 0 0 $X=157630 $Y=276965
X4258 1031 1044 223 8 1081 14 DFCND1BWP7T $T=157920 285040 1 0 $X=157630 $Y=280830
X4259 1031 1039 223 8 1032 14 DFCND1BWP7T $T=171360 292880 0 180 $X=158190 $Y=288670
X4260 1024 1089 223 8 1045 14 DFCND1BWP7T $T=173040 261520 0 180 $X=159870 $Y=257310
X4261 1031 1094 223 8 1034 14 DFCND1BWP7T $T=173040 300720 0 180 $X=159870 $Y=296510
X4262 1024 1053 223 8 1102 14 DFCND1BWP7T $T=160720 253680 0 0 $X=160430 $Y=253445
X4263 1024 1160 223 8 1105 14 DFCND1BWP7T $T=184240 269360 0 180 $X=171070 $Y=265150
X4264 1024 1115 223 8 1163 14 DFCND1BWP7T $T=171360 269360 0 0 $X=171070 $Y=269125
X4265 1024 1119 223 8 1165 14 DFCND1BWP7T $T=171920 277200 1 0 $X=171630 $Y=272990
X4266 1031 1108 223 8 1166 14 DFCND1BWP7T $T=171920 285040 1 0 $X=171630 $Y=280830
X4267 1031 1117 223 8 1134 14 DFCND1BWP7T $T=171920 292880 0 0 $X=171630 $Y=292645
X4268 1024 1144 234 8 1234 14 DFCND1BWP7T $T=185920 253680 1 0 $X=185630 $Y=249470
X4269 1031 1235 232 8 1191 14 DFCND1BWP7T $T=200480 292880 0 180 $X=187310 $Y=288670
X4270 1031 1197 232 8 1133 14 DFCND1BWP7T $T=201040 292880 1 180 $X=187870 $Y=292645
X4271 1473 1251 92 8 1545 14 DFCND1BWP7T $T=241920 245840 1 0 $X=241630 $Y=241630
X4272 1473 1485 92 8 1227 14 DFCND1BWP7T $T=241920 292880 0 0 $X=241630 $Y=292645
X4273 1473 1550 92 8 1476 14 DFCND1BWP7T $T=255920 285040 1 180 $X=242750 $Y=284805
X4274 1473 1624 92 8 1572 14 DFCND1BWP7T $T=268800 285040 1 180 $X=255630 $Y=284805
X4275 1473 1660 283 8 1722 14 DFCND1BWP7T $T=269920 292880 0 0 $X=269630 $Y=292645
X4276 1473 1683 283 8 1633 14 DFCND1BWP7T $T=285600 285040 0 180 $X=272430 $Y=280830
X4277 1473 1755 283 8 1684 14 DFCND1BWP7T $T=289520 292880 0 180 $X=276350 $Y=288670
X4278 1473 1792 283 8 1740 14 DFCND1BWP7T $T=296240 300720 0 180 $X=283070 $Y=296510
X4279 1872 1839 283 8 1805 14 DFCND1BWP7T $T=311360 300720 0 180 $X=298190 $Y=296510
X4280 1872 1856 283 8 1842 14 DFCND1BWP7T $T=316400 292880 1 180 $X=303230 $Y=292645
X4281 1872 1893 283 8 1854 14 DFCND1BWP7T $T=319200 292880 0 180 $X=306030 $Y=288670
X4282 1872 1950 283 8 1903 14 DFCND1BWP7T $T=338800 300720 0 180 $X=325630 $Y=296510
X4283 1872 1954 265 8 1992 14 DFCND1BWP7T $T=328720 277200 1 0 $X=328430 $Y=272990
X4284 1872 1952 265 8 1993 14 DFCND1BWP7T $T=328720 285040 0 0 $X=328430 $Y=284805
X4285 1872 1988 265 8 1947 14 DFCND1BWP7T $T=341600 292880 1 180 $X=328430 $Y=292645
X4286 1872 1977 265 8 2025 14 DFCND1BWP7T $T=333760 277200 0 0 $X=333470 $Y=276965
X4287 1872 1995 265 8 2013 14 DFCND1BWP7T $T=337120 269360 1 0 $X=336830 $Y=265150
X4288 cfg_mosi 8 1263 14 DEL01BWP7T $T=207760 96880 1 0 $X=207470 $Y=92670
X4289 1999 8 1071 14 DEL01BWP7T $T=337680 261520 0 180 $X=335150 $Y=257310
X4290 608 14 8 845 992 609 938 ICV_123 $T=149520 300720 1 0 $X=149230 $Y=296510
X4291 609 14 8 970 656 610 1006 ICV_123 $T=151200 292880 0 0 $X=150910 $Y=292645
X4292 610 14 8 1061 648 1071 1101 ICV_123 $T=166320 277200 1 0 $X=166030 $Y=272990
X4293 609 14 8 980 711 1071 1150 ICV_123 $T=177520 339920 0 0 $X=177230 $Y=339685
X4294 610 14 8 1178 658 1071 1202 ICV_123 $T=188160 261520 1 0 $X=187870 $Y=257310
X4295 608 14 8 1054 1208 610 1218 ICV_123 $T=190960 300720 0 0 $X=190670 $Y=300485
X4296 200 14 8 954 1275 613 1310 ICV_123 $T=205520 159600 0 0 $X=205230 $Y=159365
X4297 609 14 8 1167 717 610 1308 ICV_123 $T=206640 253680 0 0 $X=206350 $Y=253445
X4298 608 14 8 776 1517 609 777 ICV_123 $T=250880 300720 1 0 $X=250590 $Y=296510
X4299 612 14 8 422 1851 1071 1867 ICV_123 $T=304080 269360 0 0 $X=303790 $Y=269125
X4300 612 14 8 424 1888 1071 1900 ICV_123 $T=314160 269360 1 0 $X=313870 $Y=265150
X4301 200 14 8 1364 1909 1046 1918 ICV_123 $T=318640 214480 1 0 $X=318350 $Y=210270
X4302 609 14 8 1960 1969 1071 1981 ICV_123 $T=334320 332080 0 0 $X=334030 $Y=331845
X4303 800 802 811 8 797 14 OAI21D0BWP7T $T=96880 183120 0 0 $X=96590 $Y=182885
X4304 907 397 819 8 843 14 OAI21D0BWP7T $T=117040 167440 0 180 $X=113950 $Y=163230
X4305 887 881 876 8 827 14 OAI21D0BWP7T $T=123760 159600 1 180 $X=120670 $Y=159365
X4306 1425 1416 44 8 1414 14 OAI21D0BWP7T $T=233520 167440 1 180 $X=230430 $Y=167205
X4307 513 512 1592 8 1586 14 OAI21D0BWP7T $T=258720 112560 1 0 $X=258430 $Y=108350
X4308 1651 1653 1539 8 1650 14 OAI21D0BWP7T $T=272720 104720 0 180 $X=269630 $Y=100510
X4309 1864 198 1887 8 1870 14 OAI21D0BWP7T $T=309120 261520 1 0 $X=308830 $Y=257310
X4310 1882 198 1899 8 1884 14 OAI21D0BWP7T $T=312480 253680 0 0 $X=312190 $Y=253445
X4311 1904 198 1976 8 1911 14 OAI21D0BWP7T $T=319200 253680 0 0 $X=318910 $Y=253445
X4312 108 1964 139 8 1714 14 OAI21D0BWP7T $T=336000 143920 0 180 $X=332910 $Y=139710
X4313 616 1964 139 8 1715 14 OAI21D0BWP7T $T=336560 143920 1 180 $X=333470 $Y=143685
X4314 139 321 1783 8 434 14 DFKSND1BWP7T $T=311360 175280 1 180 $X=297630 $Y=175045
X4315 139 322 1783 8 433 14 DFKSND1BWP7T $T=324800 175280 1 180 $X=311070 $Y=175045
X4316 139 388 1843 8 2015 14 DFKSND1BWP7T $T=330400 183120 0 0 $X=330110 $Y=182885
X4317 1610 1620 725 1670 8 1625 14 AOI211XD0BWP7T $T=264320 190960 0 0 $X=264030 $Y=190725
X4318 205 1946 640 612 8 1940 14 AOI211XD0BWP7T $T=331520 245840 1 180 $X=327870 $Y=245605
X4319 265 8 236 14 BUFFD1P5BWP7T $T=152880 128240 0 180 $X=149790 $Y=124030
X4320 265 8 234 14 BUFFD1P5BWP7T $T=153440 167440 1 180 $X=150350 $Y=167205
X4321 265 8 223 14 BUFFD1P5BWP7T $T=154000 253680 0 180 $X=150910 $Y=249470
X4322 265 8 232 14 BUFFD1P5BWP7T $T=163520 324240 0 0 $X=163230 $Y=324005
X4323 265 8 73 14 BUFFD1P5BWP7T $T=250320 159600 1 0 $X=250030 $Y=155390
X4324 796 8 1214 14 BUFFD1P5BWP7T $T=274400 253680 1 180 $X=271310 $Y=253445
X4325 265 8 297 14 BUFFD1P5BWP7T $T=319760 159600 1 0 $X=319470 $Y=155390
X4326 265 8 139 14 BUFFD1P5BWP7T $T=321440 151760 0 0 $X=321150 $Y=151525
X4327 265 8 283 14 BUFFD1P5BWP7T $T=330400 316400 0 180 $X=327310 $Y=312190
X4338 14 8 38 36 39 ICV_125 $T=119280 183120 0 0 $X=118990 $Y=182885
X4339 14 8 942 406 960 ICV_125 $T=140000 190960 1 0 $X=139710 $Y=186750
X4340 14 8 588 1267 1252 ICV_125 $T=207200 379120 0 0 $X=206910 $Y=378885
X4341 14 8 597 1343 596 ICV_125 $T=216160 245840 0 0 $X=215870 $Y=245605
X4342 14 8 1318 1363 1329 ICV_125 $T=220640 277200 0 0 $X=220350 $Y=276965
X4343 14 8 596 1382 1400 ICV_125 $T=225120 245840 1 0 $X=224830 $Y=241630
X4344 14 8 421 1622 1675 ICV_125 $T=269920 175280 0 0 $X=269630 $Y=175045
X4345 14 8 427 429 1719 ICV_125 $T=287840 238000 0 0 $X=287550 $Y=237765
X4346 14 8 1773 423 1786 ICV_125 $T=287840 253680 0 0 $X=287550 $Y=253445
X4347 14 8 432 1939 612 ICV_125 $T=325920 238000 1 0 $X=325630 $Y=233790
X4356 100 1421 8 631 14 IND2D2BWP7T $T=235760 339920 0 180 $X=230990 $Y=335710
X4357 180 846 8 789 14 IND2D2BWP7T $T=236320 206640 1 180 $X=231550 $Y=206405
X4358 1857 438 8 98 14 IND2D2BWP7T $T=310800 245840 1 0 $X=310510 $Y=241630
X4359 1138 1247 8 1157 14 DFD0BWP7T $T=203280 238000 0 180 $X=191790 $Y=233790
X4360 1138 1248 8 1200 14 DFD0BWP7T $T=203280 245840 1 180 $X=191790 $Y=245605
X4361 1138 1278 8 1164 14 DFD0BWP7T $T=210000 222320 1 180 $X=198510 $Y=222085
X4362 1180 1355 8 1294 14 DFD0BWP7T $T=225680 214480 0 180 $X=214190 $Y=210270
X4363 1461 1443 8 1411 14 DFD0BWP7T $T=240800 198800 0 180 $X=229310 $Y=194590
X4364 1461 1491 8 1510 14 DFD0BWP7T $T=243040 206640 1 0 $X=242750 $Y=202430
X4365 1461 1528 8 1577 14 DFD0BWP7T $T=248080 206640 0 0 $X=247790 $Y=206405
X4366 1461 1585 8 1614 14 DFD0BWP7T $T=255920 214480 1 0 $X=255630 $Y=210270
X4367 1796 1782 8 1748 14 DFD0BWP7T $T=295680 214480 0 180 $X=284190 $Y=210270
X4368 1461 1831 8 1862 14 DFD0BWP7T $T=298480 198800 1 0 $X=298190 $Y=194590
X4369 1796 1813 8 1864 14 DFD0BWP7T $T=299040 253680 0 0 $X=298750 $Y=253445
X4370 1796 1835 8 1849 14 DFD0BWP7T $T=299600 214480 0 0 $X=299310 $Y=214245
X4371 1796 1844 8 642 14 DFD0BWP7T $T=304080 238000 1 0 $X=303790 $Y=233790
X4372 1796 1855 8 1882 14 DFD0BWP7T $T=306880 245840 0 0 $X=306590 $Y=245605
X4373 1796 1866 8 1904 14 DFD0BWP7T $T=310240 253680 1 0 $X=309950 $Y=249470
X4374 1398 1415 1451 726 8 1426 14 AN4D0BWP7T $T=236880 355600 0 0 $X=236590 $Y=355365
X4375 1666 1730 1741 727 8 1746 14 AN4D0BWP7T $T=282240 308560 0 0 $X=281950 $Y=308325
X4376 1803 1784 1769 728 8 1788 14 AN4D0BWP7T $T=296800 308560 1 180 $X=292590 $Y=308325
X4377 1700 1827 1820 729 8 1840 14 AN4D0BWP7T $T=300160 339920 0 0 $X=299870 $Y=339685
X4378 612 636 627 511 8 1800 14 AO22D0BWP7T $T=290080 261520 0 0 $X=289790 $Y=261285
X4379 614 1837 1642 1802 8 1809 14 AO22D0BWP7T $T=304640 245840 0 180 $X=299870 $Y=241630
X4380 612 677 614 112 8 1771 14 AO22D0BWP7T $T=304640 261520 1 180 $X=299870 $Y=261285
X4398 510 1405 730 8 752 14 OR3D1BWP7T $T=231280 175280 0 180 $X=227070 $Y=171070
X4399 1539 69 186 8 1576 14 OR3D1BWP7T $T=253120 112560 1 0 $X=252830 $Y=108350
X4400 417 69 731 8 1653 14 OR3D1BWP7T $T=269920 104720 0 0 $X=269630 $Y=104485
X4401 1579 1795 732 8 1387 14 OR3D1BWP7T $T=295680 355600 1 180 $X=291470 $Y=355365
X4402 733 164 839 843 835 8 22 14 OA221D0BWP7T $T=117040 190960 0 180 $X=111710 $Y=186750
X4403 734 198 1157 201 1132 8 1069 14 OA221D0BWP7T $T=183680 238000 0 180 $X=178350 $Y=233790
X4404 735 198 1164 201 1130 8 1145 14 OA221D0BWP7T $T=184800 230160 0 180 $X=179470 $Y=225950
X4405 736 198 1200 201 1112 8 1179 14 OA221D0BWP7T $T=192080 238000 0 180 $X=186750 $Y=233790
X4406 737 198 1294 201 1275 8 1272 14 OA221D0BWP7T $T=211680 214480 1 180 $X=206350 $Y=214245
X4407 738 198 1411 201 1439 8 1447 14 OA221D0BWP7T $T=233520 190960 0 0 $X=233230 $Y=190725
X4408 739 1435 1408 1414 1410 8 1463 14 OA221D0BWP7T $T=235200 183120 0 0 $X=234910 $Y=182885
X4409 740 198 1510 201 1500 8 1489 14 OA221D0BWP7T $T=250320 190960 1 180 $X=244990 $Y=190725
X4410 741 1551 1544 1512 1523 8 1505 14 OA221D0BWP7T $T=254800 190960 0 180 $X=249470 $Y=186750
X4411 742 198 1577 201 1534 8 1601 14 OA221D0BWP7T $T=259280 206640 1 0 $X=258990 $Y=202430
X4412 743 198 1748 201 1790 8 1775 14 OA221D0BWP7T $T=296800 206640 0 180 $X=291470 $Y=202430
X4413 14 8 833 828 826 ICV_128 $T=112000 159600 1 180 $X=108910 $Y=159365
X4414 14 8 594 984 965 ICV_128 $T=150640 222320 0 180 $X=147550 $Y=218110
X4415 14 8 1284 769 1214 ICV_128 $T=206640 402640 0 180 $X=203550 $Y=398430
X4416 14 8 1347 490 631 ICV_128 $T=220640 269360 1 180 $X=217550 $Y=269125
X4417 14 8 1377 267 631 ICV_128 $T=225680 324240 1 180 $X=222590 $Y=324005
X4418 14 8 1413 271 1214 ICV_128 $T=230720 363440 1 180 $X=227630 $Y=363205
X4419 14 8 1682 463 1214 ICV_128 $T=273840 363440 1 180 $X=270750 $Y=363205
X4420 14 8 1695 379 1214 ICV_128 $T=275520 261520 1 180 $X=272430 $Y=261285
X4421 14 8 1758 545 1214 ICV_128 $T=285600 261520 1 180 $X=282510 $Y=261285
X4422 14 8 511 546 100 ICV_128 $T=291760 332080 0 180 $X=288670 $Y=327870
X4423 14 8 1791 567 1214 ICV_128 $T=291760 371280 1 180 $X=288670 $Y=371045
X4424 14 8 1766 380 1214 ICV_128 $T=292320 269360 1 180 $X=289230 $Y=269125
X4425 223 744 14 8 794 591 ICV_129 $T=89600 261520 1 0 $X=89310 $Y=257310
X4426 234 745 14 8 972 395 ICV_129 $T=145600 175280 1 0 $X=145310 $Y=171070
X4427 234 537 14 8 972 945 ICV_129 $T=145600 183120 1 0 $X=145310 $Y=178910
X4428 234 537 14 8 968 1019 ICV_129 $T=145600 206640 0 0 $X=145310 $Y=206405
X4429 73 389 14 8 1384 1640 ICV_129 $T=257600 136080 1 0 $X=257310 $Y=131870
X4430 73 460 14 8 1384 1535 ICV_129 $T=257600 159600 1 0 $X=257310 $Y=155390
X4431 283 746 14 8 1561 1634 ICV_129 $T=257600 324240 1 0 $X=257310 $Y=320030
X4432 297 298 14 8 1384 1798 ICV_129 $T=285600 143920 1 0 $X=285310 $Y=139710
X4433 33 31 32 8 824 14 NR3D0BWP7T $T=112560 253680 0 180 $X=109470 $Y=249470
X4434 914 747 400 8 933 14 NR3D0BWP7T $T=133840 308560 1 0 $X=133550 $Y=304350
X4435 945 748 403 8 909 14 NR3D0BWP7T $T=140560 183120 1 180 $X=137470 $Y=182885
X4436 982 749 407 8 967 14 NR3D0BWP7T $T=151760 347760 1 180 $X=148670 $Y=347525
X4437 404 750 395 8 1128 14 NR3D0BWP7T $T=163520 175280 1 0 $X=163230 $Y=171070
X4438 506 751 752 8 1176 14 NR3D0BWP7T $T=177520 175280 1 0 $X=177230 $Y=171070
X4439 1267 753 183 8 1255 14 NR3D0BWP7T $T=204400 379120 0 0 $X=204110 $Y=378885
X4440 1364 434 754 8 773 14 NR3D0BWP7T $T=223440 175280 1 180 $X=220350 $Y=175045
X4441 516 430 755 8 1335 14 NR3D0BWP7T $T=225120 167440 1 180 $X=222030 $Y=167205
X4442 1363 756 409 8 1395 14 NR3D0BWP7T $T=228480 277200 0 0 $X=228190 $Y=276965
X4443 572 58 busy 8 63 14 NR3D0BWP7T $T=234640 214480 1 180 $X=231550 $Y=214245
X4444 731 515 420 8 1688 14 NR3D0BWP7T $T=273840 104720 0 0 $X=273550 $Y=104485
X4445 1545 69 524 8 cfg_miso 14 NR3D0BWP7T $T=277200 112560 0 0 $X=276910 $Y=112325
X4446 1667 757 758 8 1655 14 NR3D0BWP7T $T=287840 167440 0 180 $X=284750 $Y=163230
X4447 223 759 14 8 794 668 ICV_130 $T=115920 277200 1 0 $X=115630 $Y=272990
X4448 223 760 14 8 916 986 ICV_130 $T=136640 324240 1 0 $X=136350 $Y=320030
X4449 234 235 14 8 972 754 ICV_130 $T=142800 183120 0 0 $X=142510 $Y=182885
X4450 234 249 14 8 1022 1097 ICV_130 $T=162400 190960 1 0 $X=162110 $Y=186750
X4451 234 745 14 8 1113 1141 ICV_130 $T=171360 190960 0 0 $X=171070 $Y=190725
X4452 73 542 14 8 1366 1453 ICV_130 $T=227360 136080 0 0 $X=227070 $Y=135845
X4453 283 761 14 8 1555 1606 ICV_130 $T=255360 316400 1 0 $X=255070 $Y=312190
X4454 92 762 14 8 1313 636 ICV_130 $T=255920 261520 0 0 $X=255630 $Y=261285
X4455 283 763 14 8 1561 1804 ICV_130 $T=283920 339920 1 0 $X=283630 $Y=335710
X4456 223 764 14 8 794 593 ICV_131 $T=86240 230160 0 0 $X=85950 $Y=229925
X4457 223 765 14 8 794 394 ICV_131 $T=86240 238000 1 0 $X=85950 $Y=233790
X4458 223 766 14 8 794 793 ICV_131 $T=86240 245840 1 0 $X=85950 $Y=241630
X4459 234 745 14 8 968 996 ICV_131 $T=142240 198800 0 0 $X=141950 $Y=198565
X4460 232 767 14 8 916 1103 ICV_131 $T=162960 363440 1 0 $X=162670 $Y=359230
X4461 232 768 14 8 1203 582 ICV_131 $T=189840 371280 1 0 $X=189550 $Y=367070
X4462 232 769 14 8 1203 1252 ICV_131 $T=197120 394800 0 0 $X=196830 $Y=394565
X4463 73 542 14 8 1183 56 ICV_131 $T=225120 151760 1 0 $X=224830 $Y=147550
X4464 283 770 14 8 1537 1704 ICV_131 $T=281120 363440 1 0 $X=280830 $Y=359230
X4465 1527 1546 187 8 1331 14 CKLNQD2BWP7T $T=252000 347760 0 0 $X=251710 $Y=347525
X4466 1549 1501 187 8 1186 14 CKLNQD2BWP7T $T=253120 269360 0 0 $X=252830 $Y=269125
X4467 1696 1701 1678 8 1175 14 CKLNQD2BWP7T $T=277760 167440 0 0 $X=277470 $Y=167205
X4468 1706 1714 1678 8 1107 14 CKLNQD2BWP7T $T=279440 136080 0 0 $X=279150 $Y=135845
X4469 1707 1715 1678 8 1055 14 CKLNQD2BWP7T $T=279440 143920 0 0 $X=279150 $Y=143685
X4470 981 985 1054 771 8 1062 14 AN4D1BWP7T $T=163520 300720 0 0 $X=163230 $Y=300485
X4471 1103 1135 1139 772 8 1152 14 AN4D1BWP7T $T=176960 347760 0 0 $X=176670 $Y=347525
X4472 1198 1128 1335 773 8 1348 14 AN4D1BWP7T $T=216720 175280 1 0 $X=216430 $Y=171070
X4473 1334 1309 1390 774 8 1412 14 AN4D1BWP7T $T=226800 316400 0 0 $X=226510 $Y=316165
X4474 1498 1488 1442 775 8 1424 14 AN4D1BWP7T $T=247520 316400 1 180 $X=243310 $Y=316165
X4475 1516 1567 677 636 8 1376 14 AN4D1BWP7T $T=257600 245840 1 180 $X=253390 $Y=245605
X4476 1578 1570 1458 776 8 1082 14 AN4D1BWP7T $T=258160 308560 0 180 $X=253950 $Y=304350
X4477 1632 1603 1484 777 8 1136 14 AN4D1BWP7T $T=264880 355600 0 180 $X=260670 $Y=351390
X4478 1749 1699 1604 511 8 77 14 AN4D1BWP7T $T=280560 379120 1 180 $X=276350 $Y=378885
X4479 1471 1504 187 8 808 14 CKLNQD4BWP7T $T=245840 253680 0 0 $X=245550 $Y=253445
X4480 1713 1725 187 8 1436 14 CKLNQD4BWP7T $T=283360 300720 0 180 $X=269630 $Y=296510
X4481 1742 1726 187 8 1027 14 CKLNQD4BWP7T $T=283360 324240 0 180 $X=269630 $Y=320030
X4482 1759 1745 187 8 920 14 CKLNQD4BWP7T $T=286720 285040 1 180 $X=272990 $Y=284805
X4483 1319 200 509 778 613 8 1244 14 AOI221D1BWP7T $T=206640 183120 0 180 $X=201310 $Y=178910
X4484 1330 200 54 779 613 8 1217 14 AOI221D1BWP7T $T=216720 159600 0 0 $X=216430 $Y=159365
X4485 1602 200 1475 780 613 8 1594 14 AOI221D1BWP7T $T=263760 167440 1 180 $X=258430 $Y=167205
X4486 1692 200 1490 781 613 8 1680 14 AOI221D1BWP7T $T=277760 167440 1 180 $X=272430 $Y=167205
X4487 851 850 853 882 8 847 14 AOI211D1BWP7T $T=115360 222320 1 0 $X=115070 $Y=218110
X4488 1679 611 1611 1622 8 1620 14 AOI211D1BWP7T $T=275520 183120 1 180 $X=271870 $Y=182885
X4489 1519 8 1303 14 CKBD6BWP7T $T=249760 292880 0 180 $X=242190 $Y=288670
X4490 clk 8 1678 14 CKBD6BWP7T $T=269920 112560 0 0 $X=269630 $Y=112325
X4491 1474 69 524 1511 8 1501 14 OAI31D0BWP7T $T=245280 112560 1 0 $X=244990 $Y=108350
X4492 1592 1605 1600 69 8 646 14 OAI31D0BWP7T $T=262080 112560 0 0 $X=261790 $Y=112325
X4493 69 1617 417 1511 8 1562 14 OAI31D0BWP7T $T=264320 104720 0 0 $X=264030 $Y=104485
X4494 750 903 8 42 14 NR2XD1BWP7T $T=124880 183120 0 0 $X=124590 $Y=182885
X4495 782 910 8 396 14 NR2XD1BWP7T $T=135520 175280 1 180 $X=131310 $Y=175045
X4496 783 421 8 66 14 NR2XD1BWP7T $T=262080 167440 1 0 $X=261790 $Y=163230
X4497 14 8 795 766 796 ICV_132 $T=92960 245840 0 0 $X=92670 $Y=245605
X4498 14 8 878 361 796 ICV_132 $T=121520 269360 0 0 $X=121230 $Y=269125
X4499 14 8 965 579 594 ICV_132 $T=147840 214480 1 0 $X=147550 $Y=210270
X4500 14 8 983 241 796 ICV_132 $T=148400 230160 0 0 $X=148110 $Y=229925
X4501 14 8 1131 470 438 ICV_132 $T=177520 332080 1 0 $X=177230 $Y=327870
X4502 14 8 1237 539 1214 ICV_132 $T=197120 355600 0 0 $X=196830 $Y=355365
X4503 14 8 1573 291 100 ICV_132 $T=259840 332080 0 0 $X=259550 $Y=331845
X4504 14 8 1589 292 1214 ICV_132 $T=259840 386960 0 0 $X=259550 $Y=386725
X4505 14 8 1590 530 1214 ICV_132 $T=260400 379120 0 0 $X=260110 $Y=378885
X4506 597 1446 784 1432 596 1435 8 14 AOI32D1BWP7T $T=239120 175280 1 180 $X=234350 $Y=175045
X4507 636 1580 785 1568 677 1551 8 14 AOI32D1BWP7T $T=259840 198800 0 180 $X=255070 $Y=194590
X4508 1421 100 8 630 14 OR2D2BWP7T $T=232400 339920 0 0 $X=232110 $Y=339685
X4509 512 573 8 417 14 OR2D2BWP7T $T=256480 112560 1 180 $X=252270 $Y=112325
X4510 155 786 787 8 846 14 ND3D2BWP7T $T=110320 206640 0 0 $X=110030 $Y=206405
X4511 788 412 789 8 1367 14 ND3D2BWP7T $T=237440 214480 0 180 $X=232110 $Y=210270
X4524 1176 405 886 1209 8 1198 14 IINR4D0BWP7T $T=188160 175280 1 0 $X=187870 $Y=171070
X4525 1349 790 62 busy 8 64 14 IINR4D0BWP7T $T=226800 214480 0 0 $X=226510 $Y=214245
X4526 791 8 265 14 BUFFD2BWP7T $T=86240 151760 1 0 $X=85950 $Y=147550
X4527 265 8 92 14 BUFFD2BWP7T $T=229040 214480 0 180 $X=225390 $Y=210270
X4528 1404 1367 done 55 8 done 14 DFXQD1BWP7T $T=231280 230160 0 180 $X=216990 $Y=225950
X4529 58 1367 busy 55 8 busy 14 DFXQD1BWP7T $T=223440 222320 0 0 $X=223150 $Y=222085
X4530 67 1041 236 8 1087 14 DFSNQD1BWP7T $T=157920 104720 1 0 $X=157630 $Y=100510
X4531 67 1087 73 8 69 14 DFSNQD1BWP7T $T=213920 104720 0 0 $X=213630 $Y=104485
X4532 ext_serial_in 8 370 14 DEL0BWP7T $T=110880 230160 1 0 $X=110590 $Y=225950
X4533 170 8 1041 14 DEL0BWP7T $T=160720 96880 0 0 $X=160430 $Y=96645
X4534 1263 8 1261 14 DEL0BWP7T $T=203280 96880 1 0 $X=202990 $Y=92670
X4537 8 26 14 TIEHBWP7T $T=101920 190960 1 0 $X=101630 $Y=186750
X4538 8 27 14 TIEHBWP7T $T=103600 190960 1 0 $X=103310 $Y=186750
*.CALIBRE WARNING SHORT Short circuit(s) detected by extraction in this cell. See extraction report for details.
.ENDS
***************************************
.SUBCKT prbs_ber_pad_FINAL_top
** N=82 EP=0 IP=256 FDC=26676
X12 1 2 7 M_PDB3AC_w_bond_and_schematic $T=17560 546380 0 270 $X=17560 $Y=485980
X13 1 2 13 M_PDB3AC_w_bond_and_schematic $T=403620 17560 0 0 $X=403220 $Y=17560
X14 1 2 16 M_PDB3AC_w_bond_and_schematic $T=546380 932440 0 180 $X=485980 $Y=845280
X15 1 2 20 M_PDB3AC_w_bond_and_schematic $T=932440 403620 0 90 $X=845280 $Y=403220
X16 1 2 11 ICV_10 $T=320855 17560 0 0 $X=320455 $Y=17560
X17 1 2 18 ICV_10 $T=651910 17560 0 0 $X=651510 $Y=17560
X18 1 2 23 ICV_10 $T=932440 155325 0 90 $X=845280 $Y=154925
X19 1 2 19 ICV_10 $T=932440 238090 0 90 $X=845280 $Y=237690
X20 1 2 19 ICV_10 $T=932440 320855 0 90 $X=845280 $Y=320455
X21 1 2 21 ICV_10 $T=932440 486380 0 90 $X=845280 $Y=485980
X22 1 2 22 ICV_10 $T=932440 569145 0 90 $X=845280 $Y=568745
X27 2 1 3 M_PVDD3AC_w_bond_and_schematic $T=215325 932440 0 180 $X=154925 $Y=845280
X28 2 1 4 M_PVDD3AC_w_bond_and_schematic $T=734675 17560 0 0 $X=734275 $Y=17560
X29 1 2 M_PVDD3VSS2AC_w_bond_and_schematic $T=17560 155325 1 90 $X=17560 $Y=154925
X30 1 2 M_PVDD3VSS2AC_w_bond_and_schematic $T=932440 794675 1 270 $X=782440 $Y=651510
X31 1 2 5 ICV_32 $T=17560 320855 0 270 $X=17560 $Y=297615
X32 1 2 6 ICV_32 $T=17560 403620 0 270 $X=17560 $Y=380380
X33 1 2 8 ICV_32 $T=17560 569145 0 270 $X=17560 $Y=545905
X34 1 2 8 ICV_32 $T=17560 651910 0 270 $X=17560 $Y=628670
X35 1 2 9 ICV_32 $T=17560 734675 0 270 $X=17560 $Y=711435
X36 1 2 14 ICV_32 $T=403620 932440 0 180 $X=380380 $Y=845280
X37 1 2 24 ICV_32 $T=734675 932440 0 180 $X=711435 $Y=845280
X38 1 2 12 ICV_33 $T=238090 932440 0 180 $X=214850 $Y=845280
X39 1 2 25 ICV_33 $T=569145 932440 0 180 $X=545905 $Y=845280
X40 1 2 26 10 ICV_34 $T=155325 17560 0 0 $X=154925 $Y=17560
X41 1 2 15 17 ICV_34 $T=486380 17560 0 0 $X=485980 $Y=17560
X42 10 11 9 5 18 16 20 2 21 22 19 12 8 1 6 7 13 15 17 14 prbs_ber_pad_top $T=225000 225000 0 0 $X=225150 $Y=225361
.ENDS
***************************************
